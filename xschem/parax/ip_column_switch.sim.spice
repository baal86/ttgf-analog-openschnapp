* NGSPICE file created from ip_column_switch_parax.ext - technology: gf180mcuD

.subckt ip_column_switch_parax vsubs cl bus en
X0 bus en cl vsubs nfet_06v0 ad=0.22p pd=1.88u as=0.22p ps=1.88u w=0.5u l=0.7u
X1 cl en bus vsubs nfet_06v0 ad=0.22p pd=1.88u as=0.22p ps=1.88u w=0.5u l=0.7u
D0 vsubs en diode_nd2ps_06v0 pj=2u area=0.25p
C0 bus cl 0.1958f
C1 cl en 0.18535f
C2 bus en 0.40443f
C3 bus vsubs 1.77793f
C4 cl vsubs 1.0866f
.ends
