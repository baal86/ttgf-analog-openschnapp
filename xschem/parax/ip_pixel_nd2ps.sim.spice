* NGSPICE file created from ip_pixel_nd2ps_parax.ext - technology: gf180mcuD

.subckt ip_pixel_nd2ps_parax vsubs vdd reset cl read
X0 siminj reset vdd vsubs.t0 nfet_06v0 ad=0.2196p pd=2.04u as=0.2196p ps=2.04u w=0.3u l=1.3u
X1 a_1048_n1526# siminj vdd vsubs.t4 nfet_06v0 ad=1.54p pd=7.88u as=1.54p ps=7.88u w=3.5u l=1.9u
D0 vsubs.t2 siminj diode_nd2ps_06v0 pj=54u area=0.16125n
X2 a_1048_n1526# read cl vsubs.t1 nfet_06v0 ad=0.2196p pd=2.04u as=0.2196p ps=2.04u w=0.3u l=0.7u
R0 vsubs.t0 vsubs.t4 617.5
R1 vsubs.t4 vsubs.t1 576.333
R2 vsubs.n0 vsubs.t1 253.844
R3 vsubs.t2 vsubs.t0 166.833
R4 vsubs.n0 vsubs.t2 4.66812
R5 vsubs vsubs.n0 2.1648
C0 read a_1048_n1526# 0.00817f
C1 cl vdd 0.07948f
C2 read siminj 0.20168f
C3 reset cl 0.2527f
C4 reset vdd 0.04378f
C5 cl a_1048_n1526# 0.01985f
C6 vdd a_1048_n1526# 0.04592f
C7 cl siminj 0.24513f
C8 vdd siminj 0.45333f
C9 reset a_1048_n1526# 0.02125f
C10 read cl 0.14846f
C11 read vdd 0.11513f
C12 reset siminj 0.76671f
C13 reset read 0.15609f
C14 siminj a_1048_n1526# 0.27877f
C15 vdd vsubs 2.8543f
C16 cl vsubs 1.3797f
C17 a_1048_n1526# vsubs 1.56524f
.ends
