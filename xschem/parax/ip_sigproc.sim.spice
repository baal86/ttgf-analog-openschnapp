* NGSPICE file created from ip_sigproc_parax.ext - technology: gf180mcuD

.subckt ip_sigproc_parax REF VSUBS OUTP SIG VDD
X0 VDD.t22 a_1592_368# s1_out VDD.t24 pfet_03v3 ad=5.28p pd=24.88u as=6.015p ps=13.1u w=12u l=0.5u
X1 a_24600_1700# a_27722_1960# VSUBS.t30 ppolyf_u_1k r_width=1u r_length=15u
X2 s1_out w_13700_140# cap_pmos_03v3 c_width=13.5u c_length=18u
X3 VSUBS.t23 a_1080_400# a_1404_2016# VSUBS.t22 nfet_03v3 ad=3.03p pd=7.2u as=3.03p ps=7.2u w=6u l=2u
X4 a_32386_1878# a_29792_368# a_32574_1878# VDD.t8 pfet_03v3 ad=3.03p pd=7.2u as=3.03p ps=7.2u w=6u l=0.5u
X5 a_29604_368# a_29280_400# a_29792_368# VSUBS.t14 nfet_03v3 ad=3.03p pd=7.2u as=3.03p ps=7.2u w=6u l=0.5u
X6 a_29280_400# a_29280_400# a_29604_2016# VSUBS.t11 nfet_03v3 ad=3.03p pd=7.2u as=3.03p ps=7.2u w=6u l=0.5u
X7 a_6130_2884# w_13700_140# cap_pmos_03v3 c_width=13.5u c_length=18u
X8 a_29000_2922# a_29280_400# VSUBS.t10 ppolyf_u_1k r_width=1u r_length=12u
X9 a_240_2922# a_520_400# VSUBS.t9 ppolyf_u_1k r_width=1u r_length=12u
X10 a_18380_2922# a_18100_400# w_13700_140# ppolyf_u_1k r_width=1u r_length=12u
X11 s1_out a_6130_2884# VSUBS.t40 VSUBS.t39 nfet_03v3 ad=6.03p pd=13.2u as=6.03p ps=13.2u w=12u l=0.5u
X12 VSUBS.t15 a_29280_400# a_29604_368# VSUBS.t14 nfet_03v3 ad=2.64p pd=12.88u as=3.03p ps=7.2u w=6u l=2u
X13 a_800_2922# a_1080_400# VSUBS.t16 ppolyf_u_1k r_width=1u r_length=12u
X14 a_32386_1878# a_29792_368# a_32574_1878# VDD.t6 pfet_03v3 ad=3.03p pd=7.2u as=3.03p ps=7.2u w=6u l=0.5u
X15 s1_out a_6130_2884# VSUBS.t36 VSUBS.t39 nfet_03v3 ad=6.03p pd=13.2u as=5.28p ps=24.88u w=12u l=0.5u
X16 a_24600_1180# a_27722_1440# VSUBS.t27 ppolyf_u_1k r_width=1u r_length=15u
X17 s2_out a_29792_368# VDD.t13 VDD.t12 pfet_03v3 ad=6.015p pd=13.1u as=5.28p ps=24.88u w=12u l=0.5u
X18 a_24600_2740# a_27722_2480# VSUBS.t7 ppolyf_u_1k r_width=1u r_length=15u
X19 VSUBS.t40 a_6130_2884# s1_out VSUBS.t39 nfet_03v3 ad=5.28p pd=24.88u as=6.03p ps=13.2u w=12u l=0.5u
X20 VSUBS.t2 a_34330_536# a_34330_2884# VSUBS.t28 nfet_03v3 ad=2.64p pd=12.88u as=2.64p ps=12.88u w=6u l=5u
X21 VSUBS.t40 a_6130_2884# s1_out VSUBS.t39 nfet_03v3 ad=6.03p pd=13.2u as=6.03p ps=13.2u w=12u l=0.5u
X22 a_47700_2922# w_41900_140# w_41900_140# ppolyf_u_1k r_width=1u r_length=12u
X23 a_29280_400# a_29280_400# a_29604_2016# VSUBS.t11 nfet_03v3 ad=3.03p pd=7.2u as=2.64p ps=12.88u w=6u l=0.5u
X24 VDD.t13 a_29792_368# s2_out VDD.t14 pfet_03v3 ad=5.28p pd=24.88u as=6.015p ps=13.1u w=12u l=0.5u
X25 a_47140_2922# a_47420_400# w_41900_140# ppolyf_u_1k r_width=1u r_length=12u
X26 a_19500_2922# a_19220_400# w_13700_140# ppolyf_u_1k r_width=1u r_length=12u
X27 VDD.t10 a_29792_368# a_32386_1878# VDD.t9 pfet_03v3 ad=2.64p pd=12.88u as=3.03p ps=7.2u w=6u l=2u
X28 a_29604_2016# a_29280_400# a_29280_400# VSUBS.t11 nfet_03v3 ad=3.03p pd=7.2u as=3.03p ps=7.2u w=6u l=0.5u
X29 a_34330_2884# w_41900_140# cap_pmos_03v3 c_width=13.5u c_length=18u
X30 a_46580_2922# a_46860_400# w_41900_140# ppolyf_u_1k r_width=1u r_length=12u
X31 a_18940_2922# a_18660_400# w_13700_140# ppolyf_u_1k r_width=1u r_length=12u
X32 a_4374_1878# a_1592_368# a_4186_1878# VDD.t15 pfet_03v3 ad=3.03p pd=7.2u as=2.64p ps=12.88u w=6u l=0.5u
X33 a_28440_2922# a_28720_400# VSUBS.t10 ppolyf_u_1k r_width=1u r_length=12u
X34 a_46020_2922# a_46300_400# w_41900_140# ppolyf_u_1k r_width=1u r_length=12u
X35 a_24600_2220# a_27722_1960# VSUBS.t0 ppolyf_u_1k r_width=1u r_length=15u
X36 s2_out w_41900_140# cap_pmos_03v3 c_width=13.5u c_length=18u
X37 a_17820_2922# VDD.t25 w_13700_140# ppolyf_u_1k r_width=1u r_length=12u
X38 a_1592_368# a_1592_368# a_4186_430# VDD.t15 pfet_03v3 ad=3.03p pd=7.2u as=2.64p ps=12.88u w=6u l=0.5u
X39 VSUBS.t36 a_6130_536# a_6130_536# VSUBS.t35 nfet_03v3 ad=2.64p pd=12.88u as=2.64p ps=12.88u w=6u l=5u
X40 a_4186_430# a_1592_368# a_1592_368# VDD.t18 pfet_03v3 ad=3.03p pd=7.2u as=3.03p ps=7.2u w=6u l=0.5u
X41 a_29604_2016# a_29280_400# VSUBS.t12 VSUBS.t11 nfet_03v3 ad=2.64p pd=12.88u as=3.03p ps=7.2u w=6u l=2u
X42 a_24600_660# s2_fb VSUBS.t33 ppolyf_u_1k r_width=1u r_length=15u
X43 a_24600_1700# a_27722_1440# VSUBS.t34 ppolyf_u_1k r_width=1u r_length=15u
X44 a_240_2922# VDD.t2 VSUBS.t17 ppolyf_u_1k r_width=1u r_length=12u
X45 a_1080_400# a_1080_400# a_1404_2016# VSUBS.t20 nfet_03v3 ad=3.03p pd=7.2u as=3.03p ps=7.2u w=6u l=0.5u
X46 a_4186_1878# a_1592_368# a_4374_1878# VDD.t18 pfet_03v3 ad=3.03p pd=7.2u as=3.03p ps=7.2u w=6u l=0.5u
X47 a_4186_430# a_1592_368# a_1592_368# VDD.t16 pfet_03v3 ad=3.03p pd=7.2u as=3.03p ps=7.2u w=6u l=0.5u
X48 a_34330_2884# REF a_32574_1878# VDD.t1 pfet_03v3 ad=8.294p pd=37.56u as=7.92p ps=36.88u w=18u l=5u
X49 VSUBS.t36 a_6130_536# a_6130_2884# VSUBS.t37 nfet_03v3 ad=2.64p pd=12.88u as=2.64p ps=12.88u w=6u l=5u
X50 a_29604_2016# a_29280_400# a_29280_400# VSUBS.t11 nfet_03v3 ad=3.03p pd=7.2u as=3.03p ps=7.2u w=6u l=0.5u
X51 VDD.t23 a_1592_368# a_4186_430# VDD.t19 pfet_03v3 ad=2.64p pd=12.88u as=3.03p ps=7.2u w=6u l=2u
X52 a_24600_2740# s2_out VSUBS.t26 ppolyf_u_1k r_width=1u r_length=15u
X53 a_4374_1878# s1_out a_6130_536# VDD.t3 pfet_03v3 ad=7.92p pd=36.88u as=7.92p ps=36.88u w=18u l=5u
X54 VSUBS.t12 a_29280_400# a_29604_2016# VSUBS.t11 nfet_03v3 ad=3.03p pd=7.2u as=3.03p ps=7.2u w=6u l=2u
X55 a_1080_400# a_1080_400# a_1404_2016# VSUBS.t18 nfet_03v3 ad=3.03p pd=7.2u as=2.64p ps=12.88u w=6u l=0.5u
X56 a_29792_368# a_29792_368# a_32386_430# VDD.t7 pfet_03v3 ad=3.03p pd=7.2u as=3.03p ps=7.2u w=6u l=0.5u
X57 a_1592_368# a_1592_368# a_4186_430# VDD.t17 pfet_03v3 ad=3.03p pd=7.2u as=3.03p ps=7.2u w=6u l=0.5u
X58 a_4186_1878# a_1592_368# a_4374_1878# VDD.t16 pfet_03v3 ad=3.03p pd=7.2u as=3.03p ps=7.2u w=6u l=0.5u
X59 VSUBS.t3 a_34330_2884# s2_out VSUBS.t1 nfet_03v3 ad=6.03p pd=13.2u as=6.03p ps=13.2u w=12u l=0.5u
X60 a_29792_368# a_29792_368# a_32386_430# VDD.t5 pfet_03v3 ad=3.03p pd=7.2u as=2.64p ps=12.88u w=6u l=0.5u
X61 a_29792_368# a_29280_400# a_29604_368# VSUBS.t14 nfet_03v3 ad=3.03p pd=7.2u as=2.64p ps=12.88u w=6u l=0.5u
X62 a_19500_2922# w_13700_140# w_13700_140# ppolyf_u_1k r_width=1u r_length=12u
X63 VSUBS.t2 a_34330_536# a_34330_536# VSUBS.t29 nfet_03v3 ad=2.64p pd=12.88u as=2.64p ps=12.88u w=6u l=5u
X64 a_18940_2922# a_19220_400# w_13700_140# ppolyf_u_1k r_width=1u r_length=12u
X65 a_1592_368# a_1080_400# a_1404_368# VSUBS.t20 nfet_03v3 ad=3.03p pd=7.2u as=3.03p ps=7.2u w=6u l=0.5u
X66 a_47140_2922# a_46860_400# w_41900_140# ppolyf_u_1k r_width=1u r_length=12u
X67 a_32386_430# a_29792_368# a_29792_368# VDD.t8 pfet_03v3 ad=3.03p pd=7.2u as=3.03p ps=7.2u w=6u l=0.5u
X68 a_46580_2922# a_46300_400# w_41900_140# ppolyf_u_1k r_width=1u r_length=12u
X69 a_29000_2922# a_28720_400# VSUBS.t10 ppolyf_u_1k r_width=1u r_length=12u
X70 a_18380_2922# a_18660_400# w_13700_140# ppolyf_u_1k r_width=1u r_length=12u
X71 a_800_2922# a_520_400# VSUBS.t32 ppolyf_u_1k r_width=1u r_length=12u
X72 s2_out a_34330_2884# VSUBS.t3 VSUBS.t1 nfet_03v3 ad=6.03p pd=13.2u as=6.03p ps=13.2u w=12u l=0.5u
X73 a_28440_2922# VDD.t4 VSUBS.t10 ppolyf_u_1k r_width=1u r_length=12u
X74 a_1592_368# a_1080_400# a_1404_368# VSUBS.t18 nfet_03v3 ad=3.03p pd=7.2u as=2.64p ps=12.88u w=6u l=0.5u
X75 a_46020_2922# VDD.t0 w_41900_140# ppolyf_u_1k r_width=1u r_length=12u
X76 a_17820_2922# a_18100_400# w_13700_140# ppolyf_u_1k r_width=1u r_length=12u
X77 a_32386_430# a_29792_368# a_29792_368# VDD.t6 pfet_03v3 ad=3.03p pd=7.2u as=3.03p ps=7.2u w=6u l=0.5u
X78 a_29604_368# a_29280_400# a_29792_368# VSUBS.t14 nfet_03v3 ad=3.03p pd=7.2u as=3.03p ps=7.2u w=6u l=0.5u
X79 VDD.t20 a_1592_368# a_4186_1878# VDD.t19 pfet_03v3 ad=2.64p pd=12.88u as=3.03p ps=7.2u w=6u l=2u
X80 a_1404_2016# a_1080_400# a_1080_400# VSUBS.t21 nfet_03v3 ad=3.03p pd=7.2u as=3.03p ps=7.2u w=6u l=0.5u
X81 a_24600_660# a_27722_920# VSUBS.t8 ppolyf_u_1k r_width=1u r_length=15u
X82 a_32574_1878# a_29792_368# a_32386_1878# VDD.t7 pfet_03v3 ad=3.03p pd=7.2u as=3.03p ps=7.2u w=6u l=0.5u
X83 s2_out a_34330_2884# VSUBS.t2 VSUBS.t1 nfet_03v3 ad=6.03p pd=13.2u as=5.28p ps=24.88u w=12u l=0.5u
X84 a_1404_368# a_1080_400# a_1592_368# VSUBS.t21 nfet_03v3 ad=3.03p pd=7.2u as=3.03p ps=7.2u w=6u l=0.5u
X85 VDD.t11 a_29792_368# a_32386_430# VDD.t9 pfet_03v3 ad=2.64p pd=12.88u as=3.03p ps=7.2u w=6u l=2u
X86 a_32574_1878# s2_fb a_34330_536# VDD.t1 pfet_03v3 ad=7.92p pd=36.88u as=7.92p ps=36.88u w=18u l=5u
X87 VSUBS.t3 a_34330_2884# s2_out VSUBS.t1 nfet_03v3 ad=5.28p pd=24.88u as=6.03p ps=13.2u w=12u l=0.5u
X88 a_1404_368# a_1080_400# a_1592_368# VSUBS.t19 nfet_03v3 ad=3.03p pd=7.2u as=3.03p ps=7.2u w=6u l=0.5u
X89 a_24600_1180# a_27722_920# VSUBS.t38 ppolyf_u_1k r_width=1u r_length=15u
X90 a_1404_2016# a_1080_400# a_1080_400# VSUBS.t19 nfet_03v3 ad=3.03p pd=7.2u as=3.03p ps=7.2u w=6u l=0.5u
X91 a_4374_1878# a_1592_368# a_4186_1878# VDD.t17 pfet_03v3 ad=3.03p pd=7.2u as=3.03p ps=7.2u w=6u l=0.5u
X92 a_32574_1878# a_29792_368# a_32386_1878# VDD.t5 pfet_03v3 ad=3.03p pd=7.2u as=2.64p ps=12.88u w=6u l=0.5u
X93 VSUBS.t25 a_1080_400# a_1404_368# VSUBS.t22 nfet_03v3 ad=2.64p pd=12.88u as=3.03p ps=7.2u w=6u l=2u
X94 s2_out OUTP VSUBS.t43 ppolyf_u_1k r_width=10u r_length=5u
X95 a_24600_2220# a_27722_2480# VSUBS.t6 ppolyf_u_1k r_width=1u r_length=15u
X96 s1_out a_1592_368# VDD.t22 VDD.t21 pfet_03v3 ad=6.015p pd=13.1u as=5.28p ps=24.88u w=12u l=0.5u
X97 a_1404_2016# a_1080_400# VSUBS.t23 VSUBS.t24 nfet_03v3 ad=2.64p pd=12.88u as=3.03p ps=7.2u w=6u l=2u
X98 a_47700_2922# a_47420_400# w_41900_140# ppolyf_u_1k r_width=1u r_length=12u
X99 s1_out s2_fb VSUBS.t31 ppolyf_u_1k r_width=1u r_length=15u
X100 a_29792_368# a_29280_400# a_29604_368# VSUBS.t14 nfet_03v3 ad=3.03p pd=7.2u as=3.03p ps=7.2u w=6u l=0.5u
X101 a_6130_2884# SIG a_4374_1878# VDD.t3 pfet_03v3 ad=8.294p pd=37.56u as=7.92p ps=36.88u w=18u l=5u
R0 VDD.t1 VDD.t12 721.385
R1 VDD.t3 VDD.t21 721.385
R2 VDD.t9 VDD.t0 542.768
R3 VDD.t19 VDD.t2 542.768
R4 VDD.n8 VDD.n6 0.205961
R5 VDD.n9 VDD.n7 0.205961
R6 VDD.n8 VDD.t0 307.44
R7 VDD.n0 VDD.n5 151.849
R8 VDD.n9 VDD.t2 307.44
R9 VDD.n1 VDD.n3 151.849
R10 VDD.n5 VDD.t0 3.10736
R11 VDD.n3 VDD.t2 3.10736
R12 VDD.n4 VDD.t1 160.377
R13 VDD.n2 VDD.t3 160.377
R14 VDD.t8 VDD.t9 141.51
R15 VDD.t18 VDD.t19 141.51
R16 VDD.n0 VDD.t5 105.242
R17 VDD.n1 VDD.t15 105.242
R18 VDD.t14 VDD.n8 102.727
R19 VDD.t24 VDD.n9 102.727
R20 VDD.t5 VDD.t6 94.3401
R21 VDD.t6 VDD.t7 94.3401
R22 VDD.t7 VDD.t8 94.3401
R23 VDD.t12 VDD.t14 94.3401
R24 VDD.t15 VDD.t16 94.3401
R25 VDD.t16 VDD.t17 94.3401
R26 VDD.t17 VDD.t18 94.3401
R27 VDD.t21 VDD.t24 94.3401
R28 VDD.n6 VDD.n4 7.2039
R29 VDD.n7 VDD.n2 7.2039
R30 VDD.n1 VDD.t20 5.3105
R31 VDD.n0 VDD.t10 5.3105
R32 VDD.n5 VDD.n4 3.12014
R33 VDD.n3 VDD.n2 3.12014
R34 VDD.t11 VDD.n0 5.1005
R35 VDD.t23 VDD.n1 5.1005
R36 VDD.t0 VDD.t13 3.8705
R37 VDD.t2 VDD.t22 3.8705
R38 VDD.t25 VDD.t2 3.1565
R39 VDD.n7 VDD.t22 3.0059
R40 VDD.n6 VDD.t13 3.0059
R41 VDD.t0 VDD.t11 2.31828
R42 VDD.t2 VDD.t23 2.31828
R43 VDD.n4 VDD.t10 2.27796
R44 VDD.n2 VDD.t20 2.27796
R45 VDD.t4 VDD.t0 2.1185
R46 VDD VDD.t25 2.1005
R47 VDD VDD.t4 1.0865
R48 VSUBS.n33 VSUBS.n32 242826
R49 VSUBS.n24 VSUBS.n18 242826
R50 VSUBS.n29 VSUBS.n28 242821
R51 VSUBS.n28 VSUBS.n16 242821
R52 VSUBS.n32 VSUBS.n31 144219
R53 VSUBS.n30 VSUBS.n18 144219
R54 VSUBS.n22 VSUBS.n17 144219
R55 VSUBS.n23 VSUBS.n22 144219
R56 VSUBS.n31 VSUBS.t28 1136.3
R57 VSUBS.t37 VSUBS.n17 1136.3
R58 VSUBS.t29 VSUBS.n30 1068.89
R59 VSUBS.n23 VSUBS.t35 1068.89
R60 VSUBS.t1 VSUBS.t29 962.963
R61 VSUBS.t35 VSUBS.t39 962.963
R62 VSUBS.n12 VSUBS.n10 7.11264
R63 VSUBS.n11 VSUBS.n10 6.99206
R64 VSUBS.t28 VSUBS.t1 852.222
R65 VSUBS.t39 VSUBS.t37 852.222
R66 VSUBS.n25 VSUBS.n6 847
R67 VSUBS.n19 VSUBS.n7 847
R68 VSUBS.n13 VSUBS.n7 847
R69 VSUBS.n5 VSUBS.n9 847
R70 VSUBS.n4 VSUBS.n26 847
R71 VSUBS.n4 VSUBS.n14 847
R72 VSUBS.n15 VSUBS.t43 769.01
R73 VSUBS.n0 VSUBS.t43 716.857
R74 VSUBS.t24 VSUBS.t22 557.144
R75 VSUBS.t22 VSUBS.t21 417.858
R76 VSUBS.n22 VSUBS.t24 378.858
R77 VSUBS.t18 VSUBS.t16 336.144
R78 VSUBS.n25 VSUBS.n19 280
R79 VSUBS.n26 VSUBS.n9 280
R80 VSUBS.t19 VSUBS.t18 278.572
R81 VSUBS.t20 VSUBS.t19 278.572
R82 VSUBS.t21 VSUBS.t20 278.572
R83 VSUBS.t17 VSUBS.n10 269.44
R84 VSUBS.t9 VSUBS.t17 260
R85 VSUBS.t32 VSUBS.t9 260
R86 VSUBS.t16 VSUBS.t32 260
R87 VSUBS.n15 VSUBS.n13 227.5
R88 VSUBS.n15 VSUBS.n14 227.5
R89 VSUBS.t31 VSUBS.n18 171.915
R90 VSUBS.n32 VSUBS.t26 130.982
R91 VSUBS.n1 VSUBS.n9 116.9
R92 VSUBS.n0 VSUBS.n14 116.9
R93 VSUBS.n2 VSUBS.n19 115.501
R94 VSUBS.n26 VSUBS.n2 115.501
R95 VSUBS.n1 VSUBS.n25 114.1
R96 VSUBS.n0 VSUBS.n13 114.1
R97 VSUBS.t33 VSUBS.t31 106.424
R98 VSUBS.t38 VSUBS.t8 106.424
R99 VSUBS.t27 VSUBS.t38 106.424
R100 VSUBS.t34 VSUBS.t30 106.424
R101 VSUBS.t30 VSUBS.t0 106.424
R102 VSUBS.t0 VSUBS.t6 106.424
R103 VSUBS.t7 VSUBS.t26 106.424
R104 VSUBS.t11 VSUBS.t7 91.6882
R105 VSUBS.t14 VSUBS.t33 85.139
R106 VSUBS.n28 VSUBS.n0 83.5719
R107 VSUBS.t10 VSUBS.t27 74.4967
R108 VSUBS.n29 VSUBS.n7 24.095
R109 VSUBS.n4 VSUBS.n16 24.095
R110 VSUBS.n6 VSUBS.n24 24.095
R111 VSUBS.n5 VSUBS.n33 24.095
R112 VSUBS.t8 VSUBS.t14 21.2851
R113 VSUBS.n2 VSUBS.t34 20.4665
R114 VSUBS VSUBS.n5 17.8055
R115 VSUBS.n4 VSUBS.n3 17.8055
R116 VSUBS.t40 VSUBS.n21 15.8555
R117 VSUBS.n27 VSUBS.t3 15.8555
R118 VSUBS.t6 VSUBS.t11 14.736
R119 VSUBS.n4 VSUBS.t12 13.3655
R120 VSUBS.n5 VSUBS.n11 13.0872
R121 VSUBS.t15 VSUBS.n7 13.2155
R122 VSUBS.n6 VSUBS.n12 12.9407
R123 VSUBS.n30 VSUBS.n29 12.0375
R124 VSUBS.n31 VSUBS.n16 12.0375
R125 VSUBS.n24 VSUBS.n23 12.0375
R126 VSUBS.n33 VSUBS.n17 12.0375
R127 VSUBS.n2 VSUBS.n1 8.1869
R128 VSUBS.t25 VSUBS.n12 0.0986418
R129 VSUBS.n11 VSUBS.t23 0.0980759
R130 VSUBS.n21 VSUBS.n20 6.0005
R131 VSUBS VSUBS.n8 5.8655
R132 VSUBS.n15 VSUBS.n3 5.05844
R133 VSUBS.n27 VSUBS.n15 4.9055
R134 VSUBS.t12 VSUBS.n8 4.6355
R135 VSUBS.n20 VSUBS.t15 4.6055
R136 VSUBS.n1 VSUBS.t10 3.27506
R137 VSUBS.n20 VSUBS.n2 2.81138
R138 VSUBS.n21 VSUBS.n1 2.78138
R139 VSUBS.n0 VSUBS.n27 2.78138
R140 VSUBS VSUBS.n1 2.6705
R141 VSUBS.n0 VSUBS.n3 2.5355
R142 VSUBS.n2 VSUBS.n8 2.5055
R143 VSUBS.t3 VSUBS.n7 1.5005
R144 VSUBS.n6 VSUBS.t40 1.5005
R145 VSUBS.n7 VSUBS.t2 1.44204
R146 VSUBS.n6 VSUBS.t36 1.44204
R147 VSUBS.n5 VSUBS.t36 1.13326
R148 VSUBS.t2 VSUBS.n4 1.13326
C0 VDD s2_fb 2.45149f
C1 a_1592_368# a_1404_368# 1.48399f
C2 a_28440_2922# a_27722_2480# 0
C3 REF a_29792_368# 0.27009f
C4 a_6130_2884# a_4186_1878# 0.0038f
C5 s1_out a_18380_2922# 0.00148f
C6 a_34330_2884# a_29792_368# 0.54222f
C7 VDD a_28720_400# 0.09503f
C8 SIG a_6130_536# 0.01818f
C9 a_19220_400# a_18660_400# 0.0444f
C10 a_32386_430# a_34330_536# 0.00418f
C11 w_41900_140# a_47140_2922# 0.42251f
C12 s1_out a_19220_400# 0.00742f
C13 s1_out a_17820_2922# 0.00249f
C14 VDD a_32386_1878# 1.00663f
C15 a_6130_2884# a_18660_400# 0
C16 VDD a_46300_400# 0.11595f
C17 a_240_2922# a_1080_400# 0
C18 s1_out a_6130_2884# 4.4647f
C19 a_24600_660# w_13700_140# 0.01231f
C20 w_41900_140# a_34330_536# 0
C21 a_4374_1878# a_1080_400# 0
C22 a_24600_1180# w_13700_140# 0.01231f
C23 a_6130_2884# a_1592_368# 0.54f
C24 a_24600_1700# w_13700_140# 0.01231f
C25 VDD a_29604_2016# 0.24358f
C26 a_47420_400# a_46860_400# 0.0444f
C27 VDD a_32574_1878# 2.17436f
C28 s2_out a_47140_2922# 0.012f
C29 a_47700_2922# a_47140_2922# 0.0444f
C30 a_24600_2220# w_13700_140# 0.01231f
C31 s2_out a_34330_536# 1.8353f
C32 s2_out a_32386_430# 0.00444f
C33 a_29604_368# a_32386_430# 0.00113f
C34 VDD SIG 1.69534f
C35 a_520_400# a_1080_400# 0.03951f
C36 a_34330_2884# a_47420_400# 0
C37 s2_out w_41900_140# 10.0637f
C38 a_24600_660# a_24600_1180# 0.05405f
C39 w_41900_140# a_47700_2922# 0.49473f
C40 a_1404_2016# VDD 0.24358f
C41 a_24600_1180# a_24600_1700# 0.05405f
C42 a_1404_2016# a_800_2922# 0.05993f
C43 s2_out a_47700_2922# 0.01193f
C44 a_24600_1700# a_24600_2220# 0.05405f
C45 s2_out a_29604_368# 0.00173f
C46 a_1080_400# a_4186_1878# 0
C47 a_1404_2016# a_1404_368# 0.00526f
C48 VDD a_34330_536# 2.93407f
C49 VDD a_32386_430# 1.2083f
C50 w_13700_140# a_18660_400# 0.47555f
C51 s1_out w_13700_140# 8.19005f
C52 s2_out a_27722_2480# 0.08667f
C53 VDD w_41900_140# 2.93121f
C54 s2_fb REF 0.14073f
C55 a_4374_1878# a_4186_1878# 1.9199f
C56 a_6130_2884# SIG 1.16357f
C57 a_1080_400# a_1592_368# 1.23245f
C58 s2_fb a_34330_2884# 0.01209f
C59 a_29280_400# a_29792_368# 1.23245f
C60 a_46300_400# a_46860_400# 0.0444f
C61 s1_out a_4374_1878# 0.89564f
C62 a_24600_660# s1_out 0.05925f
C63 REF a_32386_1878# 0.02072f
C64 s2_out VDD 3.04468f
C65 a_24600_1180# s1_out 0
C66 VDD a_29604_368# 0.39705f
C67 a_4374_1878# a_1592_368# 1.25398f
C68 a_34330_2884# a_32386_1878# 0.0038f
C69 s2_out OUTP 0.07432f
C70 a_24600_1700# s1_out 0
C71 VDD a_6130_536# 2.9061f
C72 a_19500_2922# a_18940_2922# 0.0444f
C73 REF a_32574_1878# 1.0023f
C74 a_46020_2922# a_34330_2884# 0.02721f
C75 a_6130_536# a_4186_430# 0.00418f
C76 a_34330_2884# a_46580_2922# 0.02734f
C77 a_34330_2884# a_32574_1878# 0.0981f
C78 a_27722_1440# a_27722_1960# 0.05405f
C79 VDD a_18100_400# 0.11595f
C80 s2_fb a_29792_368# 1.35258f
C81 a_29280_400# a_27722_1440# 0
C82 a_6130_2884# a_24600_2740# 0
C83 a_29792_368# a_32386_1878# 1.19804f
C84 OUTP VDD 0.2344f
C85 a_19500_2922# a_6130_2884# 0.02981f
C86 VDD a_4186_430# 1.2083f
C87 a_1592_368# a_4186_1878# 1.19804f
C88 a_6130_2884# a_6130_536# 0.5629f
C89 a_29280_400# a_27722_920# 0
C90 s1_out a_18660_400# 0.00745f
C91 VDD a_1404_368# 0.39705f
C92 a_27722_920# a_27722_1440# 0.05405f
C93 a_1404_2016# a_1080_400# 3.68312f
C94 w_41900_140# a_46860_400# 0.47555f
C95 a_29604_2016# a_29792_368# 0.38572f
C96 REF a_34330_536# 0.01207f
C97 a_29792_368# a_32574_1878# 1.25398f
C98 a_34330_2884# a_47140_2922# 0.02772f
C99 s1_out a_1592_368# 0.52734f
C100 a_34330_2884# a_34330_536# 0.57657f
C101 a_4374_1878# SIG 1.13585f
C102 a_4186_430# a_1404_368# 0.00113f
C103 a_240_2922# a_1404_2016# 0.00389f
C104 a_29280_400# s2_fb 0.22993f
C105 w_41900_140# a_34330_2884# 7.79699f
C106 s2_out a_46860_400# 0.01051f
C107 VDD a_19220_400# 0.057f
C108 a_6130_2884# VDD 2.67472f
C109 a_18380_2922# a_18940_2922# 0.0444f
C110 s2_out REF 0.53473f
C111 a_29280_400# a_28720_400# 0.03951f
C112 a_29280_400# a_32386_1878# 0
C113 s2_out a_34330_2884# 7.42585f
C114 a_29280_400# a_28440_2922# 0
C115 a_47700_2922# a_34330_2884# 0.02981f
C116 a_6130_2884# a_18940_2922# 0.02772f
C117 s2_fb a_27722_920# 0.0607f
C118 a_29280_400# a_29604_2016# 3.68312f
C119 a_29280_400# a_32574_1878# 0
C120 w_13700_140# a_24600_2740# 0.01139f
C121 a_29792_368# a_34330_536# 0.06783f
C122 a_32386_430# a_29792_368# 2.60094f
C123 a_19500_2922# w_13700_140# 0.49473f
C124 a_29280_400# a_29000_2922# 0.0033f
C125 SIG a_4186_1878# 0.02072f
C126 w_13700_140# a_6130_536# 0
C127 VDD a_46860_400# 0.05835f
C128 a_17820_2922# a_18380_2922# 0.0444f
C129 a_6130_2884# a_18380_2922# 0.02734f
C130 s2_fb a_28720_400# 0.01462f
C131 VDD REF 1.68552f
C132 a_6130_2884# a_19220_400# 0
C133 a_17820_2922# a_6130_2884# 0.02721f
C134 s2_fb a_32386_1878# 0.00607f
C135 s1_out SIG 0.14527f
C136 VDD a_34330_2884# 2.7976f
C137 s2_out a_29792_368# 0.99238f
C138 w_13700_140# a_18100_400# 0.47678f
C139 a_4374_1878# a_6130_536# 0.09719f
C140 a_29604_368# a_29792_368# 1.48399f
C141 SIG a_1592_368# 0.27235f
C142 a_24600_2220# a_24600_2740# 0.05405f
C143 s2_fb a_29604_2016# 0.02381f
C144 s2_fb a_32574_1878# 1.01018f
C145 w_13700_140# VDD 2.8879f
C146 a_1404_2016# a_1592_368# 0.38572f
C147 VDD a_1080_400# 0.19141f
C148 w_41900_140# a_47420_400# 0.52118f
C149 a_29280_400# a_32386_430# 0.00664f
C150 w_13700_140# a_18940_2922# 0.42251f
C151 a_1080_400# a_800_2922# 0.0033f
C152 a_1080_400# a_4186_430# 0.00664f
C153 a_32574_1878# a_32386_1878# 1.9199f
C154 a_28440_2922# a_29604_2016# 0.00389f
C155 s2_out a_27722_1960# 0.00438f
C156 a_29000_2922# a_28440_2922# 0.03359f
C157 VDD a_4374_1878# 2.17436f
C158 a_24600_660# VDD 0.00455f
C159 s2_out a_47420_400# 0.01047f
C160 a_46020_2922# a_46580_2922# 0.0444f
C161 a_1080_400# a_1404_368# 1.28682f
C162 a_240_2922# a_800_2922# 0.03359f
C163 VDD a_29792_368# 6.02661f
C164 a_24600_1180# VDD 0.00147f
C165 a_4374_1878# a_4186_430# 0.0226f
C166 a_29280_400# s2_out 0.08944f
C167 a_24600_1700# VDD 0
C168 a_29000_2922# a_29604_2016# 0.05993f
C169 s2_out a_27722_1440# 0.00166f
C170 a_29280_400# a_29604_368# 1.28682f
C171 w_13700_140# a_18380_2922# 0.42251f
C172 a_27722_1960# a_27722_2480# 0.05405f
C173 a_520_400# VDD 0.09503f
C174 a_17820_2922# w_13700_140# 0.49495f
C175 w_13700_140# a_19220_400# 0.52118f
C176 s1_out a_19500_2922# 0.00123f
C177 s2_fb a_34330_536# 1.60989f
C178 s2_fb a_32386_430# 0.64114f
C179 a_6130_2884# w_13700_140# 7.81815f
C180 s2_out a_27722_920# 0
C181 s1_out a_6130_536# 2.83953f
C182 a_6130_536# a_1592_368# 0.05681f
C183 VDD a_47420_400# 0.057f
C184 a_32386_430# a_32386_1878# 0.01085f
C185 a_34330_2884# a_46860_400# 0
C186 a_6130_2884# a_4374_1878# 0.09144f
C187 a_46580_2922# a_47140_2922# 0.0444f
C188 VDD a_4186_1878# 1.00663f
C189 w_41900_140# a_46300_400# 0.47678f
C190 s2_out s2_fb 0.12684f
C191 a_18100_400# a_18660_400# 0.0444f
C192 a_29280_400# VDD 0.19141f
C193 s1_out a_18100_400# 0.00752f
C194 REF a_34330_2884# 1.04944f
C195 VDD a_27722_1440# 0.0013f
C196 s2_fb a_29604_368# 0.12443f
C197 a_34330_536# a_32574_1878# 0.09719f
C198 a_32386_430# a_32574_1878# 0.0226f
C199 a_4186_430# a_4186_1878# 0.01085f
C200 w_41900_140# a_46020_2922# 0.49495f
C201 VDD a_18660_400# 0.05835f
C202 w_41900_140# a_46580_2922# 0.42251f
C203 s1_out VDD 5.13228f
C204 s2_out a_32386_1878# 0.75748f
C205 s2_out a_46300_400# 0.01057f
C206 s2_out a_28440_2922# 0.02799f
C207 VDD a_1592_368# 6.02661f
C208 VDD a_27722_920# 0.00314f
C209 s1_out a_4186_430# 0.01705f
C210 s1_out a_18940_2922# 0.00129f
C211 s2_out a_46020_2922# 0.01319f
C212 s2_out a_46580_2922# 0.01219f
C213 a_1592_368# a_4186_430# 2.60094f
C214 s2_out a_29604_2016# 1.67957f
C215 s2_out a_32574_1878# 0.22643f
C216 a_29604_2016# a_29604_368# 0.00526f
C217 s2_out a_29000_2922# 0.02276f
C218 OUTP VSUBS 3.00876f
C219 VDD VSUBS 0.16484p
C220 a_47700_2922# VSUBS 0.09294f
C221 a_47420_400# VSUBS 0.09522f
C222 a_47140_2922# VSUBS 0.09183f
C223 a_46860_400# VSUBS 0.09522f
C224 a_46580_2922# VSUBS 0.09183f
C225 a_46300_400# VSUBS 0.09522f
C226 a_46020_2922# VSUBS 0.09294f
C227 a_34330_536# VSUBS 1.36719f
C228 a_32386_430# VSUBS 0.05768f
C229 a_32386_1878# VSUBS 2.24019f
C230 a_32574_1878# VSUBS 3.69305f
C231 a_29604_368# VSUBS 2.8981f
C232 a_29000_2922# VSUBS 0.48473f
C233 a_28720_400# VSUBS 0.47481f
C234 a_28440_2922# VSUBS 0.51615f
C235 a_29604_2016# VSUBS 1.90103f
C236 a_24600_660# VSUBS 0.4484f
C237 a_27722_920# VSUBS 0.45976f
C238 a_24600_1180# VSUBS 0.44815f
C239 a_27722_1440# VSUBS 0.45937f
C240 a_24600_1700# VSUBS 0.44817f
C241 a_27722_1960# VSUBS 0.45961f
C242 a_24600_2220# VSUBS 0.44853f
C243 a_27722_2480# VSUBS 0.4601f
C244 s2_out VSUBS 0.03071f
C245 a_24600_2740# VSUBS 0.48455f
C246 a_19500_2922# VSUBS 0.09294f
C247 a_19220_400# VSUBS 0.09522f
C248 a_18940_2922# VSUBS 0.09183f
C249 a_18660_400# VSUBS 0.09522f
C250 a_18380_2922# VSUBS 0.09183f
C251 a_18100_400# VSUBS 0.09522f
C252 a_17820_2922# VSUBS 0.09294f
C253 a_4186_430# VSUBS 0.05768f
C254 a_6130_2884# VSUBS 0.07789f
C255 a_4186_1878# VSUBS 0.01223f
C256 a_4374_1878# VSUBS 0.11438f
C257 a_1404_368# VSUBS 0.6034f
C258 a_800_2922# VSUBS 0.48473f
C259 a_520_400# VSUBS 0.47481f
C260 a_240_2922# VSUBS 0.51713f
C261 a_1404_2016# VSUBS 4.20448f
C262 w_41900_140# VSUBS 0.12227p
C263 w_13700_140# VSUBS 0.11757p
C264 VSUBS.t36 VSUBS 1.39871f
C265 VSUBS.t2 VSUBS 1.39871f
C266 VSUBS.t23 VSUBS 2.2947f
C267 VSUBS.t3 VSUBS 0.03071f
C268 VDD.t13 VSUBS 1.10589f
C269 VDD.t22 VSUBS 2.1865f
C270 VDD.t2 VSUBS 5.53036f
C271 VDD.t0 VSUBS 7.67373f
C272 VDD.n0 VSUBS 1.15407f
C273 VDD.n1 VSUBS 1.15407f
C274 VDD.n2 VSUBS 1.16102f
C275 VDD.n4 VSUBS 1.16102f
C276 VDD.t10 VSUBS 0.31164f
C277 VDD.n6 VSUBS 0.14825f
C278 VDD.t20 VSUBS 0.31164f
C279 VDD.n7 VSUBS 0.14825f
C280 VDD.n8 VSUBS 1.134f
C281 VDD.t14 VSUBS 0.75941f
C282 VDD.t12 VSUBS 3.14041f
C283 VDD.t1 VSUBS 3.39465f
C284 VDD.t9 VSUBS 2.63436f
C285 VDD.t8 VSUBS 0.90798f
C286 VDD.t7 VSUBS 0.72639f
C287 VDD.t6 VSUBS 0.72639f
C288 VDD.t5 VSUBS 0.76879f
C289 VDD.t11 VSUBS 0.31244f
C290 VDD.t4 VSUBS 1.281f
C291 VDD.n9 VSUBS 1.134f
C292 VDD.t24 VSUBS 0.75941f
C293 VDD.t21 VSUBS 3.14041f
C294 VDD.t3 VSUBS 3.39465f
C295 VDD.t19 VSUBS 2.63436f
C296 VDD.t18 VSUBS 0.90798f
C297 VDD.t17 VSUBS 0.72639f
C298 VDD.t16 VSUBS 0.72639f
C299 VDD.t15 VSUBS 0.76879f
C300 VDD.t23 VSUBS 0.31244f
C301 VDD.t25 VSUBS 2.06525f
.ends
