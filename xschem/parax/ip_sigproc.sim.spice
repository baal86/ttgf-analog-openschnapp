* NGSPICE file created from ip_sigproc_parax.ext - technology: gf180mcuD

.subckt ip_sigproc_parax REF VSUBS OUTP SIG VDD
X0 VDD.t22 a_1592_368# s1_out VDD.t23 pfet_03v3 ad=5.28p pd=24.88u as=6.015p ps=13.1u w=12u l=0.5u
X1 a_24600_800# a_27722_1200# VSUBS.t7 ppolyf_u_1k r_width=1u r_length=15u
X2 VSUBS.t22 a_1080_400# a_1404_2016# VSUBS.t21 nfet_03v3 ad=3.03p pd=7.2u as=3.03p ps=7.2u w=6u l=2u
X3 s1_out w_13700_140# cap_pmos_03v3 c_width=13.5u c_length=18u
X4 a_29280_400# a_29280_400# a_29604_2016# VSUBS.t10 nfet_03v3 ad=3.03p pd=7.2u as=3.03p ps=7.2u w=6u l=0.5u
X5 a_29604_368# a_29280_400# a_29792_368# VSUBS.t13 nfet_03v3 ad=3.03p pd=7.2u as=3.03p ps=7.2u w=6u l=0.5u
X6 a_32386_1878# a_29792_368# a_32574_1878# VDD.t6 pfet_03v3 ad=3.03p pd=7.2u as=3.03p ps=7.2u w=6u l=0.5u
X7 a_6130_2884# w_13700_140# cap_pmos_03v3 c_width=13.5u c_length=18u
X8 a_29000_2922# a_29280_400# VSUBS.t9 ppolyf_u_1k r_width=1u r_length=12u
X9 a_240_2922# a_520_400# VSUBS.t6 ppolyf_u_1k r_width=1u r_length=12u
X10 a_18380_2922# a_18100_400# w_13700_140# ppolyf_u_1k r_width=1u r_length=12u
X11 s1_out a_6130_2884# VSUBS.t27 VSUBS.t25 nfet_03v3 ad=6.03p pd=13.2u as=6.03p ps=13.2u w=12u l=0.5u
X12 VSUBS.t14 a_29280_400# a_29604_368# VSUBS.t13 nfet_03v3 ad=2.64p pd=12.88u as=3.03p ps=7.2u w=6u l=2u
X13 a_800_2922# a_1080_400# VSUBS.t16 ppolyf_u_1k r_width=1u r_length=12u
X14 s1_out a_6130_2884# VSUBS.t26 VSUBS.t25 nfet_03v3 ad=6.03p pd=13.2u as=5.28p ps=24.88u w=12u l=0.5u
X15 a_32386_1878# a_29792_368# a_32574_1878# VDD.t4 pfet_03v3 ad=3.03p pd=7.2u as=3.03p ps=7.2u w=6u l=0.5u
X16 s2_out a_29792_368# VDD.t11 VDD.t10 pfet_03v3 ad=6.015p pd=13.1u as=5.28p ps=24.88u w=12u l=0.5u
X17 VSUBS.t27 a_6130_2884# s1_out VSUBS.t25 nfet_03v3 ad=5.28p pd=24.88u as=6.03p ps=13.2u w=12u l=0.5u
X18 VSUBS.t27 a_6130_2884# s1_out VSUBS.t25 nfet_03v3 ad=6.03p pd=13.2u as=6.03p ps=13.2u w=12u l=0.5u
X19 VSUBS.t1 a_34330_536# a_34330_2884# VSUBS.t32 nfet_03v3 ad=2.64p pd=12.88u as=2.64p ps=12.88u w=6u l=5u
X20 a_29280_400# a_29280_400# a_29604_2016# VSUBS.t10 nfet_03v3 ad=3.03p pd=7.2u as=2.64p ps=12.88u w=6u l=0.5u
X21 VDD.t11 a_29792_368# s2_out VDD.t12 pfet_03v3 ad=5.28p pd=24.88u as=6.015p ps=13.1u w=12u l=0.5u
X22 a_47700_2922# w_41900_140# w_41900_140# ppolyf_u_1k r_width=1u r_length=12u
X23 a_18940_2922# a_18660_400# w_13700_140# ppolyf_u_1k r_width=1u r_length=12u
X24 a_19500_2922# a_19220_400# w_13700_140# ppolyf_u_1k r_width=1u r_length=12u
X25 a_29604_2016# a_29280_400# a_29280_400# VSUBS.t10 nfet_03v3 ad=3.03p pd=7.2u as=3.03p ps=7.2u w=6u l=0.5u
X26 VDD.t8 a_29792_368# a_32386_1878# VDD.t7 pfet_03v3 ad=2.64p pd=12.88u as=3.03p ps=7.2u w=6u l=2u
X27 a_46580_2922# a_46860_400# w_41900_140# ppolyf_u_1k r_width=1u r_length=12u
X28 a_47140_2922# a_47420_400# w_41900_140# ppolyf_u_1k r_width=1u r_length=12u
X29 a_34330_2884# w_41900_140# cap_pmos_03v3 c_width=13.5u c_length=18u
X30 a_4374_1878# a_1592_368# a_4186_1878# VDD.t14 pfet_03v3 ad=3.03p pd=7.2u as=2.64p ps=12.88u w=6u l=0.5u
X31 a_28440_2922# a_28720_400# VSUBS.t9 ppolyf_u_1k r_width=1u r_length=12u
X32 a_46020_2922# a_46300_400# w_41900_140# ppolyf_u_1k r_width=1u r_length=12u
X33 a_17820_2922# VDD.t24 w_13700_140# ppolyf_u_1k r_width=1u r_length=12u
X34 s2_out w_41900_140# cap_pmos_03v3 c_width=13.5u c_length=18u
X35 a_1592_368# a_1592_368# a_4186_430# VDD.t14 pfet_03v3 ad=3.03p pd=7.2u as=2.64p ps=12.88u w=6u l=0.5u
X36 VSUBS.t26 a_6130_536# a_6130_536# VSUBS.t31 nfet_03v3 ad=2.64p pd=12.88u as=2.64p ps=12.88u w=6u l=5u
X37 a_4186_430# a_1592_368# a_1592_368# VDD.t17 pfet_03v3 ad=3.03p pd=7.2u as=3.03p ps=7.2u w=6u l=0.5u
X38 a_240_2922# VDD.t1 VSUBS.t5 ppolyf_u_1k r_width=1u r_length=12u
X39 a_1080_400# a_1080_400# a_1404_2016# VSUBS.t19 nfet_03v3 ad=3.03p pd=7.2u as=3.03p ps=7.2u w=6u l=0.5u
X40 a_29604_2016# a_29280_400# VSUBS.t11 VSUBS.t10 nfet_03v3 ad=2.64p pd=12.88u as=3.03p ps=7.2u w=6u l=2u
X41 a_4186_1878# a_1592_368# a_4374_1878# VDD.t17 pfet_03v3 ad=3.03p pd=7.2u as=3.03p ps=7.2u w=6u l=0.5u
X42 a_4186_430# a_1592_368# a_1592_368# VDD.t15 pfet_03v3 ad=3.03p pd=7.2u as=3.03p ps=7.2u w=6u l=0.5u
X43 VSUBS.t26 a_6130_536# a_6130_2884# VSUBS.t30 nfet_03v3 ad=2.64p pd=12.88u as=2.64p ps=12.88u w=6u l=5u
X44 a_34330_2884# REF a_32574_1878# VDD.t0 pfet_03v3 ad=8.294p pd=37.56u as=7.92p ps=36.88u w=18u l=5u
X45 a_29604_2016# a_29280_400# a_29280_400# VSUBS.t10 nfet_03v3 ad=3.03p pd=7.2u as=3.03p ps=7.2u w=6u l=0.5u
X46 VDD.t20 a_1592_368# a_4186_430# VDD.t18 pfet_03v3 ad=2.64p pd=12.88u as=3.03p ps=7.2u w=6u l=2u
X47 a_4374_1878# s1_out a_6130_536# VDD.t13 pfet_03v3 ad=7.92p pd=36.88u as=7.92p ps=36.88u w=18u l=5u
X48 VSUBS.t11 a_29280_400# a_29604_2016# VSUBS.t10 nfet_03v3 ad=3.03p pd=7.2u as=3.03p ps=7.2u w=6u l=2u
X49 a_1080_400# a_1080_400# a_1404_2016# VSUBS.t17 nfet_03v3 ad=3.03p pd=7.2u as=2.64p ps=12.88u w=6u l=0.5u
X50 a_4186_1878# a_1592_368# a_4374_1878# VDD.t15 pfet_03v3 ad=3.03p pd=7.2u as=3.03p ps=7.2u w=6u l=0.5u
X51 a_1592_368# a_1592_368# a_4186_430# VDD.t16 pfet_03v3 ad=3.03p pd=7.2u as=3.03p ps=7.2u w=6u l=0.5u
X52 a_24600_1600# s2_out VSUBS.t8 ppolyf_u_1k r_width=1u r_length=15u
X53 a_29792_368# a_29792_368# a_32386_430# VDD.t5 pfet_03v3 ad=3.03p pd=7.2u as=3.03p ps=7.2u w=6u l=0.5u
X54 VSUBS.t2 a_34330_2884# s2_out VSUBS.t0 nfet_03v3 ad=6.03p pd=13.2u as=6.03p ps=13.2u w=12u l=0.5u
X55 a_19500_2922# w_13700_140# w_13700_140# ppolyf_u_1k r_width=1u r_length=12u
X56 a_29792_368# a_29280_400# a_29604_368# VSUBS.t13 nfet_03v3 ad=3.03p pd=7.2u as=2.64p ps=12.88u w=6u l=0.5u
X57 a_29792_368# a_29792_368# a_32386_430# VDD.t3 pfet_03v3 ad=3.03p pd=7.2u as=2.64p ps=12.88u w=6u l=0.5u
X58 a_1592_368# a_1080_400# a_1404_368# VSUBS.t19 nfet_03v3 ad=3.03p pd=7.2u as=3.03p ps=7.2u w=6u l=0.5u
X59 a_18940_2922# a_19220_400# w_13700_140# ppolyf_u_1k r_width=1u r_length=12u
X60 a_24600_800# s2_fb VSUBS.t36 ppolyf_u_1k r_width=1u r_length=15u
X61 a_32386_430# a_29792_368# a_29792_368# VDD.t6 pfet_03v3 ad=3.03p pd=7.2u as=3.03p ps=7.2u w=6u l=0.5u
X62 VSUBS.t1 a_34330_536# a_34330_536# VSUBS.t33 nfet_03v3 ad=2.64p pd=12.88u as=2.64p ps=12.88u w=6u l=5u
X63 a_47140_2922# a_46860_400# w_41900_140# ppolyf_u_1k r_width=1u r_length=12u
X64 a_800_2922# a_520_400# VSUBS.t35 ppolyf_u_1k r_width=1u r_length=12u
X65 a_1592_368# a_1080_400# a_1404_368# VSUBS.t17 nfet_03v3 ad=3.03p pd=7.2u as=2.64p ps=12.88u w=6u l=0.5u
X66 a_18380_2922# a_18660_400# w_13700_140# ppolyf_u_1k r_width=1u r_length=12u
X67 a_28440_2922# VDD.t25 VSUBS.t9 ppolyf_u_1k r_width=1u r_length=12u
X68 a_29000_2922# a_28720_400# VSUBS.t9 ppolyf_u_1k r_width=1u r_length=12u
X69 s2_out a_34330_2884# VSUBS.t2 VSUBS.t0 nfet_03v3 ad=6.03p pd=13.2u as=6.03p ps=13.2u w=12u l=0.5u
X70 a_46580_2922# a_46300_400# w_41900_140# ppolyf_u_1k r_width=1u r_length=12u
X71 a_1404_2016# a_1080_400# a_1080_400# VSUBS.t20 nfet_03v3 ad=3.03p pd=7.2u as=3.03p ps=7.2u w=6u l=0.5u
X72 VDD.t19 a_1592_368# a_4186_1878# VDD.t18 pfet_03v3 ad=2.64p pd=12.88u as=3.03p ps=7.2u w=6u l=2u
X73 a_17820_2922# a_18100_400# w_13700_140# ppolyf_u_1k r_width=1u r_length=12u
X74 a_29604_368# a_29280_400# a_29792_368# VSUBS.t13 nfet_03v3 ad=3.03p pd=7.2u as=3.03p ps=7.2u w=6u l=0.5u
X75 a_32386_430# a_29792_368# a_29792_368# VDD.t4 pfet_03v3 ad=3.03p pd=7.2u as=3.03p ps=7.2u w=6u l=0.5u
X76 a_46020_2922# VDD.t2 w_41900_140# ppolyf_u_1k r_width=1u r_length=12u
X77 a_1404_368# a_1080_400# a_1592_368# VSUBS.t20 nfet_03v3 ad=3.03p pd=7.2u as=3.03p ps=7.2u w=6u l=0.5u
X78 a_24600_1600# a_27722_1200# VSUBS.t15 ppolyf_u_1k r_width=1u r_length=15u
X79 a_32574_1878# a_29792_368# a_32386_1878# VDD.t5 pfet_03v3 ad=3.03p pd=7.2u as=3.03p ps=7.2u w=6u l=0.5u
X80 s2_out a_34330_2884# VSUBS.t1 VSUBS.t0 nfet_03v3 ad=6.03p pd=13.2u as=5.28p ps=24.88u w=12u l=0.5u
X81 VDD.t9 a_29792_368# a_32386_430# VDD.t7 pfet_03v3 ad=2.64p pd=12.88u as=3.03p ps=7.2u w=6u l=2u
X82 a_32574_1878# s2_fb a_34330_536# VDD.t0 pfet_03v3 ad=7.92p pd=36.88u as=7.92p ps=36.88u w=18u l=5u
X83 a_1404_368# a_1080_400# a_1592_368# VSUBS.t18 nfet_03v3 ad=3.03p pd=7.2u as=3.03p ps=7.2u w=6u l=0.5u
X84 VSUBS.t2 a_34330_2884# s2_out VSUBS.t0 nfet_03v3 ad=5.28p pd=24.88u as=6.03p ps=13.2u w=12u l=0.5u
X85 a_1404_2016# a_1080_400# a_1080_400# VSUBS.t18 nfet_03v3 ad=3.03p pd=7.2u as=3.03p ps=7.2u w=6u l=0.5u
X86 VSUBS.t24 a_1080_400# a_1404_368# VSUBS.t21 nfet_03v3 ad=2.64p pd=12.88u as=3.03p ps=7.2u w=6u l=2u
X87 a_4374_1878# a_1592_368# a_4186_1878# VDD.t16 pfet_03v3 ad=3.03p pd=7.2u as=3.03p ps=7.2u w=6u l=0.5u
X88 a_32574_1878# a_29792_368# a_32386_1878# VDD.t3 pfet_03v3 ad=3.03p pd=7.2u as=2.64p ps=12.88u w=6u l=0.5u
X89 a_1404_2016# a_1080_400# VSUBS.t22 VSUBS.t23 nfet_03v3 ad=2.64p pd=12.88u as=3.03p ps=7.2u w=6u l=2u
X90 s1_out a_1592_368# VDD.t22 VDD.t21 pfet_03v3 ad=6.015p pd=13.1u as=5.28p ps=24.88u w=12u l=0.5u
X91 s1_out s2_fb VSUBS.t34 ppolyf_u_1k r_width=1u r_length=15u
X92 a_47700_2922# a_47420_400# w_41900_140# ppolyf_u_1k r_width=1u r_length=12u
X93 s2_out OUTP VSUBS.t37 ppolyf_u_1k r_width=10u r_length=5u
X94 a_6130_2884# SIG a_4374_1878# VDD.t13 pfet_03v3 ad=8.294p pd=37.56u as=7.92p ps=36.88u w=18u l=5u
X95 a_29792_368# a_29280_400# a_29604_368# VSUBS.t13 nfet_03v3 ad=3.03p pd=7.2u as=3.03p ps=7.2u w=6u l=0.5u
R0 VDD.t0 VDD.t10 721.385
R1 VDD.t13 VDD.t21 721.385
R2 VDD.t7 VDD.t2 542.768
R3 VDD.t18 VDD.t1 542.768
R4 VDD.n8 VDD.n6 0.205961
R5 VDD.n9 VDD.n7 0.205961
R6 VDD.n8 VDD.t2 307.44
R7 VDD.n0 VDD.n5 151.849
R8 VDD.n9 VDD.t1 307.44
R9 VDD.n1 VDD.n3 151.849
R10 VDD.n5 VDD.t2 3.10736
R11 VDD.n3 VDD.t1 3.10736
R12 VDD.n4 VDD.t0 160.377
R13 VDD.n2 VDD.t13 160.377
R14 VDD.t6 VDD.t7 141.51
R15 VDD.t17 VDD.t18 141.51
R16 VDD.n0 VDD.t3 105.242
R17 VDD.n1 VDD.t14 105.242
R18 VDD.t12 VDD.n8 102.727
R19 VDD.t23 VDD.n9 102.727
R20 VDD.t3 VDD.t4 94.3401
R21 VDD.t4 VDD.t5 94.3401
R22 VDD.t5 VDD.t6 94.3401
R23 VDD.t10 VDD.t12 94.3401
R24 VDD.t14 VDD.t15 94.3401
R25 VDD.t15 VDD.t16 94.3401
R26 VDD.t16 VDD.t17 94.3401
R27 VDD.t21 VDD.t23 94.3401
R28 VDD.n6 VDD.n4 7.2039
R29 VDD.n7 VDD.n2 7.2039
R30 VDD.n1 VDD.t19 5.3105
R31 VDD.n0 VDD.t8 5.3105
R32 VDD.n5 VDD.n4 3.12014
R33 VDD.n3 VDD.n2 3.12014
R34 VDD.t9 VDD.n0 5.1005
R35 VDD.t20 VDD.n1 5.1005
R36 VDD.t2 VDD.t11 3.8705
R37 VDD.t1 VDD.t22 3.8705
R38 VDD.t24 VDD.t1 3.1565
R39 VDD.n7 VDD.t22 3.0059
R40 VDD.n6 VDD.t11 3.0059
R41 VDD.t2 VDD.t9 2.31828
R42 VDD.t1 VDD.t20 2.31828
R43 VDD.n4 VDD.t8 2.27796
R44 VDD.n2 VDD.t19 2.27796
R45 VDD.t25 VDD.t2 2.1185
R46 VDD VDD.t24 2.1005
R47 VDD VDD.t25 1.0865
R48 VSUBS.n33 VSUBS.n32 242826
R49 VSUBS.n24 VSUBS.n18 242826
R50 VSUBS.n29 VSUBS.n28 242821
R51 VSUBS.n28 VSUBS.n16 242821
R52 VSUBS.n32 VSUBS.n31 144219
R53 VSUBS.n30 VSUBS.n18 144219
R54 VSUBS.n22 VSUBS.n17 144219
R55 VSUBS.n23 VSUBS.n22 144219
R56 VSUBS.n31 VSUBS.t32 1136.3
R57 VSUBS.t30 VSUBS.n17 1136.3
R58 VSUBS.t33 VSUBS.n30 1068.89
R59 VSUBS.n23 VSUBS.t31 1068.89
R60 VSUBS.t0 VSUBS.t33 962.963
R61 VSUBS.t31 VSUBS.t25 962.963
R62 VSUBS.n12 VSUBS.n10 7.11264
R63 VSUBS.n11 VSUBS.n10 6.99206
R64 VSUBS.t32 VSUBS.t0 852.222
R65 VSUBS.t25 VSUBS.t30 852.222
R66 VSUBS.n25 VSUBS.n6 847
R67 VSUBS.n19 VSUBS.n7 847
R68 VSUBS.n13 VSUBS.n7 847
R69 VSUBS.n5 VSUBS.n9 847
R70 VSUBS.n4 VSUBS.n26 847
R71 VSUBS.n4 VSUBS.n14 847
R72 VSUBS.n15 VSUBS.t37 769.01
R73 VSUBS.n0 VSUBS.t37 716.857
R74 VSUBS.t23 VSUBS.t21 557.144
R75 VSUBS.t21 VSUBS.t20 417.858
R76 VSUBS.n22 VSUBS.t23 378.858
R77 VSUBS.t17 VSUBS.t16 336.144
R78 VSUBS.n32 VSUBS.t10 329.094
R79 VSUBS.n25 VSUBS.n19 280
R80 VSUBS.n26 VSUBS.n9 280
R81 VSUBS.t18 VSUBS.t17 278.572
R82 VSUBS.t19 VSUBS.t18 278.572
R83 VSUBS.t20 VSUBS.t19 278.572
R84 VSUBS.t5 VSUBS.n10 269.44
R85 VSUBS.t6 VSUBS.t5 260
R86 VSUBS.t35 VSUBS.t6 260
R87 VSUBS.t16 VSUBS.t35 260
R88 VSUBS.n15 VSUBS.n13 227.5
R89 VSUBS.n15 VSUBS.n14 227.5
R90 VSUBS.t8 VSUBS.t10 211.209
R91 VSUBS.t34 VSUBS.n18 171.915
R92 VSUBS.t36 VSUBS.t34 163.728
R93 VSUBS.t15 VSUBS.t7 163.728
R94 VSUBS.n2 VSUBS.t8 143.262
R95 VSUBS.t7 VSUBS.t13 135.894
R96 VSUBS.n1 VSUBS.n9 116.9
R97 VSUBS.n0 VSUBS.n14 116.9
R98 VSUBS.n2 VSUBS.n19 115.501
R99 VSUBS.n26 VSUBS.n2 115.501
R100 VSUBS.n1 VSUBS.n25 114.1
R101 VSUBS.n0 VSUBS.n13 114.1
R102 VSUBS.n28 VSUBS.n0 83.5719
R103 VSUBS.t13 VSUBS.t36 27.8343
R104 VSUBS.n29 VSUBS.n7 24.095
R105 VSUBS.n4 VSUBS.n16 24.095
R106 VSUBS.n6 VSUBS.n24 24.095
R107 VSUBS.n5 VSUBS.n33 24.095
R108 VSUBS VSUBS.n5 17.8055
R109 VSUBS.n4 VSUBS.n3 17.8055
R110 VSUBS.t27 VSUBS.n21 15.8555
R111 VSUBS.n27 VSUBS.t2 15.8555
R112 VSUBS.n4 VSUBS.t11 13.3655
R113 VSUBS.n5 VSUBS.n11 13.0872
R114 VSUBS.t14 VSUBS.n7 13.2155
R115 VSUBS.n6 VSUBS.n12 12.9407
R116 VSUBS.n30 VSUBS.n29 12.0375
R117 VSUBS.n31 VSUBS.n16 12.0375
R118 VSUBS.n24 VSUBS.n23 12.0375
R119 VSUBS.n33 VSUBS.n17 12.0375
R120 VSUBS.t9 VSUBS.t15 9.00554
R121 VSUBS.n2 VSUBS.n1 8.1869
R122 VSUBS.t24 VSUBS.n12 0.0986418
R123 VSUBS.n11 VSUBS.t22 0.0980759
R124 VSUBS.n21 VSUBS.n20 6.0005
R125 VSUBS VSUBS.n8 5.8655
R126 VSUBS.n15 VSUBS.n3 5.05844
R127 VSUBS.n27 VSUBS.n15 4.9055
R128 VSUBS.t11 VSUBS.n8 4.6355
R129 VSUBS.n20 VSUBS.t14 4.6055
R130 VSUBS.n1 VSUBS.t9 3.27506
R131 VSUBS.n20 VSUBS.n2 2.81138
R132 VSUBS.n21 VSUBS.n1 2.78138
R133 VSUBS.n0 VSUBS.n27 2.78138
R134 VSUBS VSUBS.n1 2.6705
R135 VSUBS.n0 VSUBS.n3 2.5355
R136 VSUBS.n2 VSUBS.n8 2.5055
R137 VSUBS.t2 VSUBS.n7 1.5005
R138 VSUBS.n6 VSUBS.t27 1.5005
R139 VSUBS.n7 VSUBS.t1 1.44204
R140 VSUBS.n6 VSUBS.t26 1.44204
R141 VSUBS.n5 VSUBS.t26 1.13326
R142 VSUBS.t1 VSUBS.n4 1.13326
C0 a_34330_536# s2_fb 1.60989f
C1 a_28440_2922# a_29604_2016# 0.00389f
C2 VDD s2_out 3.04468f
C3 a_32386_430# VDD 1.2083f
C4 a_18660_400# a_6130_2884# 0
C5 a_28720_400# s2_fb 0.01462f
C6 a_4374_1878# a_1592_368# 1.25398f
C7 a_1404_2016# a_1080_400# 3.68312f
C8 a_29604_2016# VDD 0.24358f
C9 a_1592_368# a_6130_2884# 0.54f
C10 a_19220_400# s1_out 0.00742f
C11 a_29280_400# a_27722_1200# 0
C12 w_13700_140# VDD 2.8879f
C13 a_47700_2922# w_41900_140# 0.49473f
C14 a_29604_368# VDD 0.39705f
C15 a_47140_2922# w_41900_140# 0.42251f
C16 a_24600_1600# VDD 0
C17 w_41900_140# a_46300_400# 0.47678f
C18 a_32386_1878# VDD 1.00663f
C19 a_4186_430# a_1404_368# 0.00113f
C20 a_18100_400# VDD 0.11595f
C21 a_6130_536# a_1592_368# 0.05681f
C22 a_34330_2884# s2_out 7.42585f
C23 a_32574_1878# s2_out 0.22643f
C24 w_13700_140# a_19220_400# 0.52118f
C25 a_1080_400# a_1404_368# 1.28682f
C26 a_32386_430# a_32574_1878# 0.0226f
C27 a_24600_800# VDD 0.00335f
C28 a_4186_430# VDD 1.2083f
C29 OUTP VDD 0.2344f
C30 a_18660_400# s1_out 0.00745f
C31 a_47700_2922# a_47140_2922# 0.0444f
C32 w_41900_140# VDD 2.93121f
C33 a_34330_536# VDD 2.93407f
C34 VDD a_520_400# 0.09503f
C35 a_1404_2016# a_1404_368# 0.00526f
C36 a_28720_400# VDD 0.09503f
C37 s1_out a_1592_368# 0.52734f
C38 a_1080_400# VDD 0.19141f
C39 a_46020_2922# a_46580_2922# 0.0444f
C40 a_34330_2884# a_32386_1878# 0.0038f
C41 a_32386_1878# a_32574_1878# 1.9199f
C42 a_29792_368# s2_out 0.99238f
C43 s2_fb VDD 2.44553f
C44 a_32386_430# a_29792_368# 2.60094f
C45 a_1404_2016# VDD 0.24358f
C46 w_13700_140# a_18660_400# 0.47555f
C47 a_19500_2922# a_6130_2884# 0.02981f
C48 a_29604_2016# a_29792_368# 0.38572f
C49 a_4374_1878# a_6130_2884# 0.09144f
C50 a_29604_368# a_29792_368# 1.48399f
C51 a_29280_400# s2_out 0.08944f
C52 SIG VDD 1.69534f
C53 a_32386_430# a_29280_400# 0.00664f
C54 a_34330_2884# w_41900_140# 7.79699f
C55 a_34330_2884# a_34330_536# 0.57657f
C56 a_34330_536# a_32574_1878# 0.09719f
C57 a_18100_400# a_18660_400# 0.0444f
C58 a_46300_400# VDD 0.11595f
C59 a_29604_2016# a_29280_400# 3.68312f
C60 a_28440_2922# a_29000_2922# 0.03359f
C61 a_32386_1878# a_29792_368# 1.19804f
C62 a_4186_430# a_4186_1878# 0.01085f
C63 a_29280_400# a_29604_368# 1.28682f
C64 a_6130_536# a_4374_1878# 0.09719f
C65 a_34330_2884# s2_fb 0.01209f
C66 VDD a_1404_368# 0.39705f
C67 a_32574_1878# s2_fb 1.01018f
C68 a_6130_536# a_6130_2884# 0.5629f
C69 a_1080_400# a_4186_1878# 0
C70 a_32386_1878# a_29280_400# 0
C71 a_47420_400# a_46860_400# 0.0444f
C72 a_4186_430# a_1592_368# 2.60094f
C73 a_34330_536# a_29792_368# 0.06783f
C74 a_47700_2922# a_34330_2884# 0.02981f
C75 s1_out a_19500_2922# 0.00123f
C76 a_47140_2922# a_34330_2884# 0.02772f
C77 a_4374_1878# s1_out 0.89564f
C78 a_46020_2922# s2_out 0.01319f
C79 s2_out REF 0.53473f
C80 a_1080_400# a_1592_368# 1.23245f
C81 s1_out a_6130_2884# 4.4647f
C82 a_27722_1200# s2_out 0.03418f
C83 a_29792_368# s2_fb 1.35258f
C84 s2_out a_46580_2922# 0.01219f
C85 SIG a_4186_1878# 0.02072f
C86 a_28720_400# a_29280_400# 0.03951f
C87 a_1404_2016# a_1592_368# 0.38572f
C88 a_19220_400# VDD 0.057f
C89 w_13700_140# a_19500_2922# 0.49473f
C90 a_29280_400# s2_fb 0.22937f
C91 a_6130_536# s1_out 2.83953f
C92 a_32386_1878# REF 0.02072f
C93 SIG a_1592_368# 0.27235f
C94 a_47420_400# s2_out 0.01047f
C95 a_34330_2884# VDD 2.7976f
C96 w_13700_140# a_6130_2884# 7.81815f
C97 a_46860_400# s2_out 0.01051f
C98 a_32574_1878# VDD 2.17436f
C99 a_18380_2922# a_6130_2884# 0.02734f
C100 VDD a_4186_1878# 1.00663f
C101 a_1592_368# a_1404_368# 1.48399f
C102 a_46020_2922# w_41900_140# 0.49495f
C103 a_6130_536# w_13700_140# 0
C104 a_34330_536# REF 0.01207f
C105 a_4186_430# a_4374_1878# 0.0226f
C106 a_18660_400# VDD 0.05835f
C107 w_41900_140# a_46580_2922# 0.42251f
C108 a_29792_368# VDD 6.02661f
C109 a_29000_2922# a_29280_400# 0.0033f
C110 a_1592_368# VDD 6.02661f
C111 a_28440_2922# a_29280_400# 0
C112 a_34330_2884# a_32574_1878# 0.0981f
C113 a_4374_1878# a_1080_400# 0
C114 s2_fb REF 0.14073f
C115 s2_fb a_27722_1200# 0.02527f
C116 w_13700_140# s1_out 8.19005f
C117 a_29280_400# VDD 0.19141f
C118 a_32386_430# s2_out 0.00444f
C119 a_47420_400# w_41900_140# 0.52118f
C120 a_24600_1600# s1_out 0
C121 a_6130_536# a_4186_430# 0.00418f
C122 a_19220_400# a_18660_400# 0.0444f
C123 a_46860_400# w_41900_140# 0.47555f
C124 a_18380_2922# s1_out 0.00148f
C125 a_29604_2016# s2_out 1.68259f
C126 a_6130_2884# a_17820_2922# 0.02721f
C127 a_29604_368# s2_out 0.00173f
C128 a_18100_400# s1_out 0.00752f
C129 a_32386_430# a_29604_368# 0.00113f
C130 a_47140_2922# a_46580_2922# 0.0444f
C131 a_4374_1878# SIG 1.13585f
C132 a_34330_2884# a_29792_368# 0.54222f
C133 a_32574_1878# a_29792_368# 1.25398f
C134 a_29604_2016# a_29604_368# 0.00526f
C135 a_32386_1878# s2_out 0.75748f
C136 SIG a_6130_2884# 1.16357f
C137 a_19500_2922# a_18940_2922# 0.0444f
C138 a_32386_430# a_32386_1878# 0.01085f
C139 a_24600_800# s1_out 0.02319f
C140 a_4186_430# s1_out 0.01705f
C141 w_13700_140# a_24600_1600# 0.01231f
C142 a_240_2922# a_800_2922# 0.03359f
C143 w_13700_140# a_18380_2922# 0.42251f
C144 a_6130_2884# a_18940_2922# 0.02772f
C145 a_29280_400# a_32574_1878# 0
C146 a_1592_368# a_4186_1878# 1.19804f
C147 w_13700_140# a_18100_400# 0.47678f
C148 VDD REF 1.68552f
C149 OUTP s2_out 0.07432f
C150 a_240_2922# a_1080_400# 0
C151 a_6130_536# SIG 0.01818f
C152 a_46860_400# a_46300_400# 0.0444f
C153 w_41900_140# s2_out 10.0637f
C154 VDD a_27722_1200# 0.00153f
C155 a_34330_536# s2_out 1.8353f
C156 a_32386_430# a_34330_536# 0.00418f
C157 a_4374_1878# VDD 2.17436f
C158 s1_out a_17820_2922# 0.00249f
C159 w_13700_140# a_24600_800# 0.01231f
C160 a_240_2922# a_1404_2016# 0.00389f
C161 VDD a_6130_2884# 2.67472f
C162 a_24600_1600# a_24600_800# 0.01636f
C163 s2_fb s2_out 0.14312f
C164 a_29280_400# a_29792_368# 1.23245f
C165 a_32386_430# s2_fb 0.64114f
C166 SIG s1_out 0.14527f
C167 a_47420_400# VDD 0.057f
C168 a_46860_400# VDD 0.05835f
C169 a_29604_2016# s2_fb 0.02381f
C170 a_34330_2884# a_46020_2922# 0.02721f
C171 a_34330_2884# REF 1.04944f
C172 s1_out a_18940_2922# 0.00129f
C173 a_29604_368# s2_fb 0.12394f
C174 w_13700_140# a_17820_2922# 0.49495f
C175 a_6130_536# VDD 2.9061f
C176 a_47700_2922# s2_out 0.01193f
C177 a_32574_1878# REF 1.0023f
C178 a_47140_2922# s2_out 0.012f
C179 a_19220_400# a_6130_2884# 0
C180 a_34330_2884# a_46580_2922# 0.02734f
C181 a_18380_2922# a_17820_2922# 0.0444f
C182 a_46300_400# s2_out 0.01057f
C183 a_32386_1878# s2_fb 0.00607f
C184 a_34330_536# w_41900_140# 0
C185 a_4186_430# a_1080_400# 0.00664f
C186 a_800_2922# a_1080_400# 0.0033f
C187 a_29000_2922# s2_out 0.0199f
C188 a_4374_1878# a_4186_1878# 1.9199f
C189 s1_out VDD 5.13228f
C190 a_28440_2922# s2_out 0.0199f
C191 w_13700_140# a_18940_2922# 0.42251f
C192 a_34330_2884# a_47420_400# 0
C193 a_1080_400# a_520_400# 0.03951f
C194 a_29792_368# REF 0.27009f
C195 a_34330_2884# a_46860_400# 0
C196 a_6130_2884# a_4186_1878# 0.0038f
C197 a_29604_2016# a_29000_2922# 0.05993f
C198 a_18380_2922# a_18940_2922# 0.0444f
C199 a_800_2922# a_1404_2016# 0.05993f
C200 OUTP VSUBS 3.00876f
C201 VDD VSUBS 0.16485p
C202 a_47700_2922# VSUBS 0.09294f
C203 a_47420_400# VSUBS 0.09522f
C204 a_47140_2922# VSUBS 0.09183f
C205 a_46860_400# VSUBS 0.09522f
C206 a_46580_2922# VSUBS 0.09183f
C207 a_46300_400# VSUBS 0.09522f
C208 a_46020_2922# VSUBS 0.09294f
C209 a_34330_536# VSUBS 1.35768f
C210 a_32386_430# VSUBS 0.05768f
C211 a_32386_1878# VSUBS 1.09284f
C212 a_32574_1878# VSUBS 2.53619f
C213 a_29604_368# VSUBS 0.6034f
C214 a_29000_2922# VSUBS 0.48473f
C215 a_28720_400# VSUBS 0.47481f
C216 a_28440_2922# VSUBS 0.51713f
C217 a_29604_2016# VSUBS 4.18906f
C218 a_24600_800# VSUBS 0.57761f
C219 a_27722_1200# VSUBS 0.58435f
C220 s2_out VSUBS 0.03071f
C221 a_24600_1600# VSUBS 0.59956f
C222 a_19500_2922# VSUBS 0.09294f
C223 a_19220_400# VSUBS 0.09522f
C224 a_18940_2922# VSUBS 0.09183f
C225 a_18660_400# VSUBS 0.09522f
C226 a_18380_2922# VSUBS 0.09183f
C227 a_18100_400# VSUBS 0.09522f
C228 a_17820_2922# VSUBS 0.09294f
C229 a_4186_430# VSUBS 0.05768f
C230 a_6130_2884# VSUBS 0.07789f
C231 a_4186_1878# VSUBS 0.01223f
C232 a_4374_1878# VSUBS 0.11438f
C233 a_1404_368# VSUBS 0.6034f
C234 a_800_2922# VSUBS 0.48473f
C235 a_520_400# VSUBS 0.47481f
C236 a_240_2922# VSUBS 0.51713f
C237 a_1404_2016# VSUBS 4.20448f
C238 w_41900_140# VSUBS 0.12265p
C239 w_13700_140# VSUBS 0.11758p
C240 VSUBS.t26 VSUBS 1.39871f
C241 VSUBS.t1 VSUBS 1.39871f
C242 VSUBS.t22 VSUBS 2.2947f
C243 VSUBS.t2 VSUBS 0.03071f
C244 VDD.t11 VSUBS 1.10566f
C245 VDD.t22 VSUBS 2.18626f
C246 VDD.t1 VSUBS 5.52921f
C247 VDD.t2 VSUBS 7.67213f
C248 VDD.n0 VSUBS 1.15383f
C249 VDD.n1 VSUBS 1.15383f
C250 VDD.n2 VSUBS 1.16078f
C251 VDD.n4 VSUBS 1.16078f
C252 VDD.t8 VSUBS 0.31157f
C253 VDD.n6 VSUBS 0.14822f
C254 VDD.t19 VSUBS 0.31157f
C255 VDD.n7 VSUBS 0.14822f
C256 VDD.n8 VSUBS 1.13376f
C257 VDD.t12 VSUBS 0.75926f
C258 VDD.t10 VSUBS 3.13976f
C259 VDD.t0 VSUBS 3.39394f
C260 VDD.t7 VSUBS 2.63381f
C261 VDD.t6 VSUBS 0.90779f
C262 VDD.t5 VSUBS 0.72623f
C263 VDD.t4 VSUBS 0.72623f
C264 VDD.t3 VSUBS 0.76863f
C265 VDD.t9 VSUBS 0.31237f
C266 VDD.t25 VSUBS 1.28073f
C267 VDD.n9 VSUBS 1.13376f
C268 VDD.t23 VSUBS 0.75926f
C269 VDD.t21 VSUBS 3.13976f
C270 VDD.t13 VSUBS 3.39394f
C271 VDD.t18 VSUBS 2.63381f
C272 VDD.t17 VSUBS 0.90779f
C273 VDD.t16 VSUBS 0.72623f
C274 VDD.t15 VSUBS 0.72623f
C275 VDD.t14 VSUBS 0.76863f
C276 VDD.t20 VSUBS 0.31237f
C277 VDD.t24 VSUBS 2.06482f
.ends
