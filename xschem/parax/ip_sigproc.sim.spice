* NGSPICE file created from ip_sigproc_parax.ext - technology: gf180mcuD

.subckt ip_sigproc_parax REF VSUBS OUTP SIG VDD
X0 a_24600_2200# a_27722_1920# VSUBS.t21 ppolyf_u_1k r_width=1u r_length=15u
X1 a_24600_520# s2_fb VSUBS.t42 ppolyf_u_1k r_width=1u r_length=15u
X2 VDD.t10 a_1612_368# s1_out VDD.t11 pfet_03v3 ad=5.28p pd=24.88u as=6.015p ps=13.1u w=12u l=0.5u
X3 a_1424_2016# a_1080_400# a_1080_400# VSUBS.t24 nfet_03v3 ad=3.03p pd=7.2u as=3.03p ps=7.2u w=6u l=0.5u
X4 s1_out w_13700_140# cap_pmos_03v3 c_width=13.5u c_length=18u
X5 a_32386_1878# a_29812_368# a_32574_1878# VDD.t18 pfet_03v3 ad=3.03p pd=7.2u as=3.03p ps=7.2u w=6u l=0.5u
X6 a_29000_2922# a_29280_400# VSUBS.t7 ppolyf_u_1k r_width=1u r_length=12u
X7 a_1424_2016# a_1080_400# VSUBS.t28 VSUBS.t29 nfet_03v3 ad=2.64p pd=12.88u as=3.03p ps=7.2u w=6u l=2u
X8 a_240_2922# a_520_400# VSUBS.t11 ppolyf_u_1k r_width=1u r_length=12u
X9 s1_out a_6130_2884# VSUBS.t17 VSUBS.t16 nfet_03v3 ad=6.03p pd=13.2u as=6.03p ps=13.2u w=12u l=0.5u
X10 a_800_2922# a_1080_400# VSUBS.t6 ppolyf_u_1k r_width=1u r_length=12u
X11 a_47720_2942# w_41900_140# w_41900_140# ppolyf_u_1k r_width=1u r_length=12u
X12 a_32386_1878# a_29812_368# a_32574_1878# VDD.t16 pfet_03v3 ad=3.03p pd=7.2u as=3.03p ps=7.2u w=6u l=0.5u
X13 s1_out a_6130_2884# VSUBS.t9 VSUBS.t16 nfet_03v3 ad=6.03p pd=13.2u as=5.28p ps=24.88u w=12u l=0.5u
X14 a_47160_2942# a_47440_420# w_41900_140# ppolyf_u_1k r_width=1u r_length=12u
X15 s2_out a_29812_368# VDD.t22 VDD.t21 pfet_03v3 ad=6.015p pd=13.1u as=5.28p ps=24.88u w=12u l=0.5u
X16 a_24600_1080# a_27722_800# VSUBS.t41 ppolyf_u_1k r_width=1u r_length=15u
X17 a_19520_2942# a_19240_420# w_13700_140# ppolyf_u_1k r_width=1u r_length=12u
X18 VSUBS.t28 a_1080_400# a_1424_2016# VSUBS.t27 nfet_03v3 ad=3.03p pd=7.2u as=3.03p ps=7.2u w=6u l=2u
X19 a_29280_400# a_29280_400# a_29624_2016# VSUBS.t1 nfet_03v3 ad=3.03p pd=7.2u as=3.03p ps=7.2u w=6u l=0.5u
X20 a_46600_2942# a_46880_420# w_41900_140# ppolyf_u_1k r_width=1u r_length=12u
X21 a_18960_2942# a_18680_420# w_13700_140# ppolyf_u_1k r_width=1u r_length=12u
X22 VSUBS.t17 a_6130_2884# s1_out VSUBS.t16 nfet_03v3 ad=5.28p pd=24.88u as=6.03p ps=13.2u w=12u l=0.5u
X23 a_46040_2942# a_46320_420# w_41900_140# ppolyf_u_1k r_width=1u r_length=12u
X24 a_18400_2942# a_18120_420# w_13700_140# ppolyf_u_1k r_width=1u r_length=12u
X25 a_24600_1640# a_27722_1920# VSUBS.t31 ppolyf_u_1k r_width=1u r_length=15u
X26 VSUBS.t33 a_34330_536# a_34330_2884# VSUBS.t37 nfet_03v3 ad=2.64p pd=12.88u as=2.64p ps=12.88u w=6u l=5u
X27 a_17840_2942# VDD.t25 w_13700_140# ppolyf_u_1k r_width=1u r_length=12u
X28 VSUBS.t17 a_6130_2884# s1_out VSUBS.t16 nfet_03v3 ad=6.03p pd=13.2u as=6.03p ps=13.2u w=12u l=0.5u
X29 VDD.t22 a_29812_368# s2_out VDD.t24 pfet_03v3 ad=5.28p pd=24.88u as=6.015p ps=13.1u w=12u l=0.5u
X30 a_6130_2884# w_13700_140# cap_pmos_03v3 c_width=13.5u c_length=18u
X31 VDD.t20 a_29812_368# a_32386_1878# VDD.t19 pfet_03v3 ad=2.64p pd=12.88u as=3.03p ps=7.2u w=6u l=2u
X32 s1_out s2_fb VSUBS.t14 ppolyf_u_1k r_width=1u r_length=15u
X33 a_24600_2760# s2_out VSUBS.t15 ppolyf_u_1k r_width=1u r_length=15u
X34 a_4374_1878# a_1612_368# a_4186_1878# VDD.t2 pfet_03v3 ad=3.03p pd=7.2u as=2.64p ps=12.88u w=6u l=0.5u
X35 a_28440_2922# a_28720_400# VSUBS.t7 ppolyf_u_1k r_width=1u r_length=12u
X36 s2_out w_41900_140# cap_pmos_03v3 c_width=13.5u c_length=18u
X37 a_29812_368# a_29280_400# a_29624_368# VSUBS.t4 nfet_03v3 ad=3.03p pd=7.2u as=2.64p ps=12.88u w=6u l=0.5u
X38 a_1612_368# a_1612_368# a_4186_430# VDD.t2 pfet_03v3 ad=3.03p pd=7.2u as=2.64p ps=12.88u w=6u l=0.5u
X39 VSUBS.t9 a_6130_536# a_6130_536# VSUBS.t8 nfet_03v3 ad=2.64p pd=12.88u as=2.64p ps=12.88u w=6u l=5u
X40 a_29280_400# a_29280_400# a_29624_2016# VSUBS.t1 nfet_03v3 ad=3.03p pd=7.2u as=2.64p ps=12.88u w=6u l=0.5u
X41 a_1612_368# a_1080_400# a_1424_368# VSUBS.t25 nfet_03v3 ad=3.03p pd=7.2u as=3.03p ps=7.2u w=6u l=0.5u
X42 a_4186_430# a_1612_368# a_1612_368# VDD.t5 pfet_03v3 ad=3.03p pd=7.2u as=3.03p ps=7.2u w=6u l=0.5u
X43 a_29624_2016# a_29280_400# a_29280_400# VSUBS.t1 nfet_03v3 ad=3.03p pd=7.2u as=3.03p ps=7.2u w=6u l=0.5u
X44 a_240_2922# VDD.t14 VSUBS.t22 ppolyf_u_1k r_width=1u r_length=12u
X45 a_1612_368# a_1080_400# a_1424_368# VSUBS.t23 nfet_03v3 ad=3.03p pd=7.2u as=2.64p ps=12.88u w=6u l=0.5u
X46 a_4186_1878# a_1612_368# a_4374_1878# VDD.t5 pfet_03v3 ad=3.03p pd=7.2u as=3.03p ps=7.2u w=6u l=0.5u
X47 a_4186_430# a_1612_368# a_1612_368# VDD.t3 pfet_03v3 ad=3.03p pd=7.2u as=3.03p ps=7.2u w=6u l=0.5u
X48 a_34330_2884# REF a_32574_1878# VDD.t12 pfet_03v3 ad=8.294p pd=37.56u as=7.92p ps=36.88u w=18u l=5u
X49 VSUBS.t9 a_6130_536# a_6130_2884# VSUBS.t10 nfet_03v3 ad=2.64p pd=12.88u as=2.64p ps=12.88u w=6u l=5u
X50 a_1424_368# a_1080_400# a_1612_368# VSUBS.t26 nfet_03v3 ad=3.03p pd=7.2u as=3.03p ps=7.2u w=6u l=0.5u
X51 a_24600_1640# a_27722_1360# VSUBS.t40 ppolyf_u_1k r_width=1u r_length=15u
X52 VDD.t8 a_1612_368# a_4186_430# VDD.t6 pfet_03v3 ad=2.64p pd=12.88u as=3.03p ps=7.2u w=6u l=2u
X53 a_34330_2884# w_41900_140# cap_pmos_03v3 c_width=13.5u c_length=18u
X54 a_47160_2942# a_46880_420# w_41900_140# ppolyf_u_1k r_width=1u r_length=12u
X55 a_18960_2942# a_19240_420# w_13700_140# ppolyf_u_1k r_width=1u r_length=12u
X56 a_4374_1878# s1_out a_6130_536# VDD.t0 pfet_03v3 ad=7.92p pd=36.88u as=7.92p ps=36.88u w=18u l=5u
X57 a_29624_368# a_29280_400# a_29812_368# VSUBS.t4 nfet_03v3 ad=3.03p pd=7.2u as=3.03p ps=7.2u w=6u l=0.5u
X58 a_18400_2942# a_18680_420# w_13700_140# ppolyf_u_1k r_width=1u r_length=12u
X59 a_1424_368# a_1080_400# a_1612_368# VSUBS.t24 nfet_03v3 ad=3.03p pd=7.2u as=3.03p ps=7.2u w=6u l=0.5u
X60 a_24600_2760# a_27722_2480# VSUBS.t12 ppolyf_u_1k r_width=1u r_length=15u
X61 a_29812_368# a_29812_368# a_32386_430# VDD.t17 pfet_03v3 ad=3.03p pd=7.2u as=3.03p ps=7.2u w=6u l=0.5u
X62 a_1612_368# a_1612_368# a_4186_430# VDD.t4 pfet_03v3 ad=3.03p pd=7.2u as=3.03p ps=7.2u w=6u l=0.5u
X63 a_29624_2016# a_29280_400# VSUBS.t2 VSUBS.t1 nfet_03v3 ad=2.64p pd=12.88u as=3.03p ps=7.2u w=6u l=2u
X64 a_4186_1878# a_1612_368# a_4374_1878# VDD.t3 pfet_03v3 ad=3.03p pd=7.2u as=3.03p ps=7.2u w=6u l=0.5u
X65 a_46040_2942# VDD.t1 w_41900_140# ppolyf_u_1k r_width=1u r_length=12u
X66 a_17840_2942# a_18120_420# w_13700_140# ppolyf_u_1k r_width=1u r_length=12u
X67 VSUBS.t34 a_34330_2884# s2_out VSUBS.t32 nfet_03v3 ad=6.03p pd=13.2u as=6.03p ps=13.2u w=12u l=0.5u
X68 a_1080_400# a_1080_400# a_1424_2016# VSUBS.t25 nfet_03v3 ad=3.03p pd=7.2u as=3.03p ps=7.2u w=6u l=0.5u
X69 VSUBS.t30 a_1080_400# a_1424_368# VSUBS.t27 nfet_03v3 ad=2.64p pd=12.88u as=3.03p ps=7.2u w=6u l=2u
X70 a_29812_368# a_29812_368# a_32386_430# VDD.t15 pfet_03v3 ad=3.03p pd=7.2u as=2.64p ps=12.88u w=6u l=0.5u
X71 VSUBS.t33 a_34330_536# a_34330_536# VSUBS.t38 nfet_03v3 ad=2.64p pd=12.88u as=2.64p ps=12.88u w=6u l=5u
X72 a_29812_368# a_29280_400# a_29624_368# VSUBS.t4 nfet_03v3 ad=3.03p pd=7.2u as=3.03p ps=7.2u w=6u l=0.5u
X73 a_24600_520# a_27722_800# VSUBS.t20 ppolyf_u_1k r_width=1u r_length=15u
X74 a_32386_430# a_29812_368# a_29812_368# VDD.t18 pfet_03v3 ad=3.03p pd=7.2u as=3.03p ps=7.2u w=6u l=0.5u
X75 a_29000_2922# a_28720_400# VSUBS.t7 ppolyf_u_1k r_width=1u r_length=12u
X76 a_800_2922# a_520_400# VSUBS.t0 ppolyf_u_1k r_width=1u r_length=12u
X77 s2_out a_34330_2884# VSUBS.t34 VSUBS.t32 nfet_03v3 ad=6.03p pd=13.2u as=6.03p ps=13.2u w=12u l=0.5u
X78 VSUBS.t2 a_29280_400# a_29624_2016# VSUBS.t1 nfet_03v3 ad=3.03p pd=7.2u as=3.03p ps=7.2u w=6u l=2u
X79 a_28440_2922# VDD.t13 VSUBS.t7 ppolyf_u_1k r_width=1u r_length=12u
X80 a_32386_430# a_29812_368# a_29812_368# VDD.t16 pfet_03v3 ad=3.03p pd=7.2u as=3.03p ps=7.2u w=6u l=0.5u
X81 a_1080_400# a_1080_400# a_1424_2016# VSUBS.t23 nfet_03v3 ad=3.03p pd=7.2u as=2.64p ps=12.88u w=6u l=0.5u
X82 VDD.t7 a_1612_368# a_4186_1878# VDD.t6 pfet_03v3 ad=2.64p pd=12.88u as=3.03p ps=7.2u w=6u l=2u
X83 a_32574_1878# a_29812_368# a_32386_1878# VDD.t17 pfet_03v3 ad=3.03p pd=7.2u as=3.03p ps=7.2u w=6u l=0.5u
X84 s2_out a_34330_2884# VSUBS.t33 VSUBS.t32 nfet_03v3 ad=6.03p pd=13.2u as=5.28p ps=24.88u w=12u l=0.5u
X85 a_29624_368# a_29280_400# a_29812_368# VSUBS.t4 nfet_03v3 ad=3.03p pd=7.2u as=3.03p ps=7.2u w=6u l=0.5u
X86 a_47720_2942# a_47440_420# w_41900_140# ppolyf_u_1k r_width=1u r_length=12u
X87 a_19520_2942# w_13700_140# w_13700_140# ppolyf_u_1k r_width=1u r_length=12u
X88 VDD.t23 a_29812_368# a_32386_430# VDD.t19 pfet_03v3 ad=2.64p pd=12.88u as=3.03p ps=7.2u w=6u l=2u
X89 a_32574_1878# s2_fb a_34330_536# VDD.t12 pfet_03v3 ad=7.92p pd=36.88u as=7.92p ps=36.88u w=18u l=5u
X90 VSUBS.t34 a_34330_2884# s2_out VSUBS.t32 nfet_03v3 ad=5.28p pd=24.88u as=6.03p ps=13.2u w=12u l=0.5u
X91 a_46600_2942# a_46320_420# w_41900_140# ppolyf_u_1k r_width=1u r_length=12u
X92 a_24600_1080# a_27722_1360# VSUBS.t13 ppolyf_u_1k r_width=1u r_length=15u
X93 s2_out OUTP VSUBS.t43 ppolyf_u_1k r_width=10u r_length=5u
X94 a_4374_1878# a_1612_368# a_4186_1878# VDD.t4 pfet_03v3 ad=3.03p pd=7.2u as=3.03p ps=7.2u w=6u l=0.5u
X95 a_32574_1878# a_29812_368# a_32386_1878# VDD.t15 pfet_03v3 ad=3.03p pd=7.2u as=2.64p ps=12.88u w=6u l=0.5u
X96 VSUBS.t5 a_29280_400# a_29624_368# VSUBS.t4 nfet_03v3 ad=2.64p pd=12.88u as=3.03p ps=7.2u w=6u l=2u
X97 a_24600_2200# a_27722_2480# VSUBS.t39 ppolyf_u_1k r_width=1u r_length=15u
X98 s1_out a_1612_368# VDD.t10 VDD.t9 pfet_03v3 ad=6.015p pd=13.1u as=5.28p ps=24.88u w=12u l=0.5u
X99 a_1424_2016# a_1080_400# a_1080_400# VSUBS.t26 nfet_03v3 ad=3.03p pd=7.2u as=3.03p ps=7.2u w=6u l=0.5u
X100 a_29624_2016# a_29280_400# a_29280_400# VSUBS.t1 nfet_03v3 ad=3.03p pd=7.2u as=3.03p ps=7.2u w=6u l=0.5u
X101 a_6130_2884# SIG a_4374_1878# VDD.t0 pfet_03v3 ad=8.294p pd=37.56u as=7.92p ps=36.88u w=18u l=5u
R0 VDD.t12 VDD.t21 721.385
R1 VDD.t0 VDD.t9 721.385
R2 VDD.t19 VDD.t1 542.768
R3 VDD.t6 VDD.t14 542.768
R4 VDD.n8 VDD.n6 0.205961
R5 VDD.n9 VDD.n7 0.205961
R6 VDD.n8 VDD.t1 307.44
R7 VDD.n0 VDD.n5 151.849
R8 VDD.n9 VDD.t14 307.44
R9 VDD.n1 VDD.n3 151.849
R10 VDD.n5 VDD.t1 3.10736
R11 VDD.n3 VDD.t14 3.10736
R12 VDD.n4 VDD.t12 160.377
R13 VDD.n2 VDD.t0 160.377
R14 VDD.t18 VDD.t19 141.51
R15 VDD.t5 VDD.t6 141.51
R16 VDD.n0 VDD.t15 105.242
R17 VDD.n1 VDD.t2 105.242
R18 VDD.t24 VDD.n8 102.727
R19 VDD.t11 VDD.n9 102.727
R20 VDD.t15 VDD.t16 94.3401
R21 VDD.t16 VDD.t17 94.3401
R22 VDD.t17 VDD.t18 94.3401
R23 VDD.t21 VDD.t24 94.3401
R24 VDD.t2 VDD.t3 94.3401
R25 VDD.t3 VDD.t4 94.3401
R26 VDD.t4 VDD.t5 94.3401
R27 VDD.t9 VDD.t11 94.3401
R28 VDD.n6 VDD.n4 7.2039
R29 VDD.n7 VDD.n2 7.2039
R30 VDD.n1 VDD.t7 5.3105
R31 VDD.n0 VDD.t20 5.3105
R32 VDD.n5 VDD.n4 3.12014
R33 VDD.n3 VDD.n2 3.12014
R34 VDD.t23 VDD.n0 5.1005
R35 VDD.t8 VDD.n1 5.1005
R36 VDD.t1 VDD.t22 3.8705
R37 VDD.t14 VDD.t10 3.8705
R38 VDD.t25 VDD.t14 3.1625
R39 VDD.n7 VDD.t10 3.0059
R40 VDD.n6 VDD.t22 3.0059
R41 VDD.t1 VDD.t23 2.31828
R42 VDD.t14 VDD.t8 2.31828
R43 VDD.n4 VDD.t20 2.27796
R44 VDD.n2 VDD.t7 2.27796
R45 VDD VDD.t25 2.25725
R46 VDD.t13 VDD.t1 2.1185
R47 VDD VDD.t13 1.9475
R48 VSUBS.n33 VSUBS.n32 242826
R49 VSUBS.n24 VSUBS.n18 242826
R50 VSUBS.n29 VSUBS.n28 242821
R51 VSUBS.n28 VSUBS.n16 242821
R52 VSUBS.n32 VSUBS.n31 144219
R53 VSUBS.n30 VSUBS.n18 144219
R54 VSUBS.n22 VSUBS.n17 144219
R55 VSUBS.n23 VSUBS.n22 144219
R56 VSUBS.n31 VSUBS.t37 1136.3
R57 VSUBS.t10 VSUBS.n17 1136.3
R58 VSUBS.t38 VSUBS.n30 1068.89
R59 VSUBS.n23 VSUBS.t8 1068.89
R60 VSUBS.t32 VSUBS.t38 962.963
R61 VSUBS.t8 VSUBS.t16 962.963
R62 VSUBS.n12 VSUBS.n10 7.14201
R63 VSUBS.n11 VSUBS.n10 7.02144
R64 VSUBS.t37 VSUBS.t32 852.222
R65 VSUBS.t16 VSUBS.t10 852.222
R66 VSUBS.n25 VSUBS.n6 847
R67 VSUBS.n19 VSUBS.n7 847
R68 VSUBS.n13 VSUBS.n7 847
R69 VSUBS.n5 VSUBS.n9 847
R70 VSUBS.n4 VSUBS.n26 847
R71 VSUBS.n4 VSUBS.n14 847
R72 VSUBS.n15 VSUBS.t43 824.725
R73 VSUBS.n0 VSUBS.t43 754
R74 VSUBS.t29 VSUBS.t27 557.144
R75 VSUBS.t27 VSUBS.t26 417.858
R76 VSUBS.n22 VSUBS.t29 360.286
R77 VSUBS.t23 VSUBS.t6 354.714
R78 VSUBS.n25 VSUBS.n19 280
R79 VSUBS.n26 VSUBS.n9 280
R80 VSUBS.t24 VSUBS.t23 278.572
R81 VSUBS.t25 VSUBS.t24 278.572
R82 VSUBS.t26 VSUBS.t25 278.572
R83 VSUBS.t22 VSUBS.n10 269.44
R84 VSUBS.t11 VSUBS.t22 260
R85 VSUBS.t0 VSUBS.t11 260
R86 VSUBS.t6 VSUBS.t0 260
R87 VSUBS.n15 VSUBS.n13 234.5
R88 VSUBS.n15 VSUBS.n14 234.5
R89 VSUBS.n1 VSUBS.n9 116.9
R90 VSUBS.n0 VSUBS.n14 116.9
R91 VSUBS.n2 VSUBS.n19 115.501
R92 VSUBS.n26 VSUBS.n2 115.501
R93 VSUBS.t42 VSUBS.t14 114.611
R94 VSUBS.t20 VSUBS.t42 114.611
R95 VSUBS.t13 VSUBS.t41 114.611
R96 VSUBS.t31 VSUBS.t21 114.611
R97 VSUBS.t21 VSUBS.t39 114.611
R98 VSUBS.t12 VSUBS.t15 114.611
R99 VSUBS.n32 VSUBS.t15 114.611
R100 VSUBS.n1 VSUBS.n25 114.1
R101 VSUBS.n0 VSUBS.n13 114.1
R102 VSUBS.n2 VSUBS.t31 110.516
R103 VSUBS.t7 VSUBS.t13 107.243
R104 VSUBS.t14 VSUBS.n18 106.424
R105 VSUBS.t1 VSUBS.t12 99.8746
R106 VSUBS.t41 VSUBS.t4 86.7763
R107 VSUBS.n28 VSUBS.n0 83.5719
R108 VSUBS.t4 VSUBS.t20 27.8343
R109 VSUBS.n29 VSUBS.n7 24.095
R110 VSUBS.n4 VSUBS.n16 24.095
R111 VSUBS.n6 VSUBS.n24 24.095
R112 VSUBS.n5 VSUBS.n33 24.095
R113 VSUBS VSUBS.n5 17.8055
R114 VSUBS.n4 VSUBS.n3 17.8055
R115 VSUBS.t17 VSUBS.n21 15.8555
R116 VSUBS.n27 VSUBS.t34 15.8555
R117 VSUBS.t39 VSUBS.t1 14.736
R118 VSUBS.n4 VSUBS.t2 13.3355
R119 VSUBS.n5 VSUBS.n11 13.0578
R120 VSUBS.t5 VSUBS.n7 13.1855
R121 VSUBS.n6 VSUBS.n12 12.9113
R122 VSUBS.n30 VSUBS.n29 12.0375
R123 VSUBS.n31 VSUBS.n16 12.0375
R124 VSUBS.n24 VSUBS.n23 12.0375
R125 VSUBS.n33 VSUBS.n17 12.0375
R126 VSUBS.t30 VSUBS.n12 0.0988226
R127 VSUBS.n11 VSUBS.t28 0.098265
R128 VSUBS.n21 VSUBS.n20 6.0005
R129 VSUBS VSUBS.n8 5.8655
R130 VSUBS.n15 VSUBS.n3 5.20844
R131 VSUBS.n27 VSUBS.n15 5.0555
R132 VSUBS.t2 VSUBS.n8 4.6655
R133 VSUBS.n20 VSUBS.t5 4.6355
R134 VSUBS.t40 VSUBS.n1 4.0937
R135 VSUBS.n2 VSUBS.t40 4.0937
R136 VSUBS.n1 VSUBS.t7 3.27506
R137 VSUBS.n20 VSUBS.n2 2.81138
R138 VSUBS.n21 VSUBS.n1 2.78138
R139 VSUBS.n0 VSUBS.n27 2.78138
R140 VSUBS VSUBS.n1 2.6705
R141 VSUBS.n0 VSUBS.n3 2.5355
R142 VSUBS.n2 VSUBS.n8 2.5055
R143 VSUBS.t34 VSUBS.n7 1.5005
R144 VSUBS.n6 VSUBS.t17 1.5005
R145 VSUBS.n7 VSUBS.t33 1.44204
R146 VSUBS.n6 VSUBS.t9 1.44204
R147 VSUBS.n5 VSUBS.t9 1.13326
R148 VSUBS.t33 VSUBS.n4 1.13326
C0 a_47720_2942# a_47160_2942# 0.0444f
C1 a_24600_2200# w_13700_140# 0.01204f
C2 s2_out a_34330_536# 1.8353f
C3 s2_out a_32386_430# 0.00444f
C4 a_29624_368# a_32386_430# 0.00137f
C5 VDD SIG 1.69534f
C6 a_520_400# a_1080_400# 0.03951f
C7 a_24600_520# a_24600_1080# 0.03282f
C8 s2_out w_41900_140# 9.98696f
C9 w_41900_140# a_47720_2942# 0.48977f
C10 a_1424_2016# VDD 0.29593f
C11 a_24600_1080# a_24600_1640# 0.03282f
C12 a_1424_2016# a_800_2922# 0.04851f
C13 s2_out a_47720_2942# 0.01137f
C14 a_24600_1640# a_24600_2200# 0.03282f
C15 s2_out a_29624_368# 0.00173f
C16 a_1080_400# a_4186_1878# 0
C17 a_1424_2016# a_1424_368# 0.00526f
C18 VDD a_34330_536# 2.93407f
C19 VDD a_32386_430# 1.2083f
C20 w_13700_140# a_18680_420# 0.44898f
C21 s1_out w_13700_140# 8.18768f
C22 VDD w_41900_140# 2.93454f
C23 s2_out a_27722_2480# 0.07146f
C24 s2_fb REF 0.14073f
C25 a_4374_1878# a_4186_1878# 1.9199f
C26 a_6130_2884# SIG 1.16357f
C27 a_1080_400# a_1612_368# 1.22986f
C28 s2_fb a_34330_2884# 0.01209f
C29 a_46320_420# a_46880_420# 0.0444f
C30 a_29280_400# a_29812_368# 1.22986f
C31 s1_out a_4374_1878# 0.89564f
C32 a_24600_520# s1_out 0.0599f
C33 REF a_32386_1878# 0.02072f
C34 s2_out VDD 3.04966f
C35 a_24600_1080# s1_out 0.00112f
C36 VDD a_29624_368# 0.39701f
C37 a_4374_1878# a_1612_368# 1.25398f
C38 a_34330_2884# a_32386_1878# 0.0038f
C39 s2_out OUTP 0.07574f
C40 a_24600_1640# s1_out 0
C41 VDD a_6130_536# 2.9061f
C42 a_19520_2942# a_18960_2942# 0.0444f
C43 REF a_32574_1878# 1.0023f
C44 a_46040_2942# a_34330_2884# 0.03008f
C45 a_6130_536# a_4186_430# 0.00418f
C46 a_34330_2884# a_46600_2942# 0.03026f
C47 a_34330_2884# a_32574_1878# 0.0981f
C48 a_29280_400# a_27722_1920# 0
C49 a_27722_1360# a_27722_1920# 0.03861f
C50 VDD a_18120_420# 0.11133f
C51 s2_fb a_29812_368# 1.34551f
C52 a_29280_400# a_27722_1360# 0
C53 a_6130_2884# a_24600_2760# 0
C54 a_29812_368# a_32386_1878# 1.19804f
C55 OUTP VDD 0.24132f
C56 a_19520_2942# a_6130_2884# 0.03412f
C57 VDD a_4186_430# 1.2083f
C58 a_1612_368# a_4186_1878# 1.19804f
C59 a_6130_2884# a_6130_536# 0.5629f
C60 a_29280_400# a_27722_800# 0
C61 s1_out a_18680_420# 0.00776f
C62 VDD a_1424_368# 0.39701f
C63 a_27722_800# a_27722_1360# 0.03861f
C64 w_41900_140# a_46880_420# 0.44898f
C65 a_1424_2016# a_1080_400# 3.68312f
C66 a_29624_2016# a_29812_368# 0.37572f
C67 REF a_34330_536# 0.01207f
C68 a_29812_368# a_32574_1878# 1.25398f
C69 a_34330_2884# a_47160_2942# 0.03083f
C70 s1_out a_1612_368# 0.52734f
C71 a_34330_2884# a_34330_536# 0.57657f
C72 a_4374_1878# SIG 1.13585f
C73 a_4186_430# a_1424_368# 0.00137f
C74 a_240_2922# a_1424_2016# 0.0036f
C75 a_29280_400# s2_fb 0.23154f
C76 w_41900_140# a_34330_2884# 7.80618f
C77 s2_out a_46880_420# 0.01098f
C78 VDD a_19240_420# 0.05238f
C79 a_6130_2884# VDD 2.67082f
C80 a_18400_2942# a_18960_2942# 0.0444f
C81 a_29280_400# a_28720_400# 0.03951f
C82 s2_out REF 0.53473f
C83 a_29280_400# a_32386_1878# 0
C84 s2_out a_34330_2884# 7.42577f
C85 a_47720_2942# a_34330_2884# 0.03412f
C86 a_6130_2884# a_18960_2942# 0.03083f
C87 s2_fb a_27722_800# 0.05522f
C88 a_29280_400# a_29624_2016# 3.68312f
C89 a_29280_400# a_32574_1878# 0
C90 w_13700_140# a_24600_2760# 0.01106f
C91 a_29812_368# a_34330_536# 0.06783f
C92 a_32386_430# a_29812_368# 2.60094f
C93 a_19520_2942# w_13700_140# 0.48977f
C94 a_29280_400# a_29000_2922# 0.00322f
C95 SIG a_4186_1878# 0.02072f
C96 w_13700_140# a_6130_536# 0
C97 VDD a_46880_420# 0.05372f
C98 a_17840_2942# a_18400_2942# 0.0444f
C99 a_6130_2884# a_18400_2942# 0.03026f
C100 s2_fb a_28720_400# 0.0148f
C101 VDD REF 1.68552f
C102 a_17840_2942# a_6130_2884# 0.03008f
C103 s2_fb a_32386_1878# 0.00607f
C104 s1_out SIG 0.14527f
C105 VDD a_34330_2884# 2.7976f
C106 s2_out a_29812_368# 0.97884f
C107 w_13700_140# a_18120_420# 0.45008f
C108 a_4374_1878# a_6130_536# 0.09719f
C109 a_29624_368# a_29812_368# 1.48399f
C110 SIG a_1612_368# 0.27235f
C111 a_24600_2200# a_24600_2760# 0.03282f
C112 s2_fb a_29624_2016# 0.02381f
C113 s2_fb a_32574_1878# 1.01018f
C114 w_13700_140# VDD 2.89625f
C115 a_1424_2016# a_1612_368# 0.37572f
C116 VDD a_1080_400# 0.19582f
C117 w_41900_140# a_47440_420# 0.49422f
C118 a_29280_400# a_32386_430# 0.00683f
C119 w_13700_140# a_18960_2942# 0.43216f
C120 a_1080_400# a_800_2922# 0.00322f
C121 a_1080_400# a_4186_430# 0.00683f
C122 a_32574_1878# a_32386_1878# 1.9199f
C123 a_28440_2922# a_29624_2016# 0.0036f
C124 s2_out a_27722_1920# 0.00421f
C125 a_29000_2922# a_28440_2922# 0.03282f
C126 VDD a_4374_1878# 2.17436f
C127 a_24600_520# VDD 0.00465f
C128 s2_out a_47440_420# 0.01098f
C129 a_46040_2942# a_46600_2942# 0.0444f
C130 a_1080_400# a_1424_368# 1.14976f
C131 a_240_2922# a_800_2922# 0.03282f
C132 a_24600_1080# VDD 0.00151f
C133 VDD a_29812_368# 6.0013f
C134 a_4374_1878# a_4186_430# 0.0226f
C135 a_24600_1640# VDD 0
C136 a_29280_400# s2_out 0.08992f
C137 a_29000_2922# a_29624_2016# 0.04851f
C138 s2_out a_27722_1360# 0.00149f
C139 a_29280_400# a_29624_368# 1.14976f
C140 w_13700_140# a_18400_2942# 0.43216f
C141 a_27722_1920# a_27722_2480# 0.03861f
C142 a_520_400# VDD 0.09503f
C143 w_13700_140# a_19240_420# 0.49422f
C144 a_17840_2942# w_13700_140# 0.48998f
C145 s1_out a_19520_2942# 0.00104f
C146 s2_fb a_34330_536# 1.60989f
C147 s2_fb a_32386_430# 0.64114f
C148 a_6130_2884# w_13700_140# 7.82833f
C149 s2_out a_27722_800# 0
C150 s1_out a_6130_536# 2.83953f
C151 a_6130_536# a_1612_368# 0.05681f
C152 VDD a_47440_420# 0.05238f
C153 a_32386_430# a_32386_1878# 0.01085f
C154 a_6130_2884# a_4374_1878# 0.09144f
C155 a_46600_2942# a_47160_2942# 0.0444f
C156 VDD a_4186_1878# 1.00663f
C157 s2_out s2_fb 0.12684f
C158 a_18120_420# a_18680_420# 0.0444f
C159 w_41900_140# a_46320_420# 0.45008f
C160 a_29280_400# VDD 0.19582f
C161 s1_out a_18120_420# 0.00776f
C162 REF a_34330_2884# 1.04944f
C163 VDD a_27722_1360# 0.00104f
C164 s2_fb a_29624_368# 0.12496f
C165 a_34330_536# a_32574_1878# 0.09719f
C166 a_32386_430# a_32574_1878# 0.0226f
C167 a_4186_430# a_4186_1878# 0.01085f
C168 w_41900_140# a_46040_2942# 0.48998f
C169 VDD a_18680_420# 0.05372f
C170 w_41900_140# a_46600_2942# 0.43216f
C171 s1_out VDD 5.13459f
C172 s2_out a_32386_1878# 0.75748f
C173 s2_out a_46320_420# 0.01098f
C174 s2_out a_28440_2922# 0.02617f
C175 VDD a_1612_368# 6.0013f
C176 VDD a_27722_800# 0.00303f
C177 s1_out a_4186_430# 0.01705f
C178 s1_out a_18960_2942# 0.0011f
C179 s2_out a_46040_2942# 0.013f
C180 s2_out a_46600_2942# 0.01165f
C181 a_1612_368# a_4186_430# 2.60094f
C182 s2_out a_29624_2016# 1.67893f
C183 s2_out a_32574_1878# 0.22643f
C184 a_29624_2016# a_29624_368# 0.00526f
C185 s2_out a_29000_2922# 0.02235f
C186 VDD s2_fb 2.47651f
C187 a_1612_368# a_1424_368# 1.48399f
C188 a_28440_2922# a_27722_2480# 0
C189 REF a_29812_368# 0.27009f
C190 a_6130_2884# a_4186_1878# 0.0038f
C191 s1_out a_18400_2942# 0.00132f
C192 a_34330_2884# a_29812_368# 0.54222f
C193 VDD a_28720_400# 0.09503f
C194 SIG a_6130_536# 0.01818f
C195 a_19240_420# a_18680_420# 0.0444f
C196 a_32386_430# a_34330_536# 0.00418f
C197 w_41900_140# a_47160_2942# 0.43216f
C198 s1_out a_19240_420# 0.00776f
C199 s1_out a_17840_2942# 0.00267f
C200 VDD a_32386_1878# 1.00663f
C201 VDD a_46320_420# 0.11133f
C202 s1_out a_6130_2884# 4.46592f
C203 a_24600_520# w_13700_140# 0.01204f
C204 a_4374_1878# a_1080_400# 0
C205 w_41900_140# a_34330_536# 0
C206 a_24600_1080# w_13700_140# 0.01204f
C207 a_6130_2884# a_1612_368# 0.54f
C208 a_24600_1640# w_13700_140# 0.01204f
C209 a_47440_420# a_46880_420# 0.0444f
C210 VDD a_29624_2016# 0.29593f
C211 VDD a_32574_1878# 2.17436f
C212 s2_out a_47160_2942# 0.01144f
C213 OUTP VSUBS 2.91231f
C214 VDD VSUBS 0.16417p
C215 a_47720_2942# VSUBS 0.09407f
C216 a_47440_420# VSUBS 0.09364f
C217 a_47160_2942# VSUBS 0.09309f
C218 a_46880_420# VSUBS 0.09364f
C219 a_46600_2942# VSUBS 0.09309f
C220 a_46320_420# VSUBS 0.09364f
C221 a_46040_2942# VSUBS 0.09407f
C222 a_34330_536# VSUBS 1.42783f
C223 a_32386_430# VSUBS 0.05719f
C224 a_32386_1878# VSUBS 1.08315f
C225 a_32574_1878# VSUBS 2.59666f
C226 a_29624_368# VSUBS 0.61192f
C227 a_29000_2922# VSUBS 0.4853f
C228 a_28720_400# VSUBS 0.47481f
C229 a_28440_2922# VSUBS 0.5061f
C230 a_29624_2016# VSUBS 4.19572f
C231 a_24600_520# VSUBS 0.46432f
C232 a_27722_800# VSUBS 0.48084f
C233 a_24600_1080# VSUBS 0.46392f
C234 a_27722_1360# VSUBS 0.48031f
C235 a_24600_1640# VSUBS 0.46395f
C236 a_27722_1920# VSUBS 0.48052f
C237 a_24600_2200# VSUBS 0.46451f
C238 a_27722_2480# VSUBS 0.48061f
C239 a_24600_2760# VSUBS 0.49699f
C240 a_19520_2942# VSUBS 0.09407f
C241 a_19240_420# VSUBS 0.09364f
C242 a_18960_2942# VSUBS 0.09309f
C243 a_18680_420# VSUBS 0.09364f
C244 a_18400_2942# VSUBS 0.09309f
C245 a_18120_420# VSUBS 0.09364f
C246 a_17840_2942# VSUBS 0.09407f
C247 a_6130_536# VSUBS 1.54299f
C248 a_4186_430# VSUBS 0.05719f
C249 a_6130_2884# VSUBS 0.07789f
C250 a_4186_1878# VSUBS 0.01223f
C251 a_4374_1878# VSUBS 1.65738f
C252 a_1424_368# VSUBS 0.61192f
C253 a_800_2922# VSUBS 0.4853f
C254 a_520_400# VSUBS 0.47481f
C255 a_240_2922# VSUBS 0.50703f
C256 a_1424_2016# VSUBS 4.20264f
C257 w_41900_140# VSUBS 0.12239p
C258 w_13700_140# VSUBS 0.11146p
C259 VSUBS.t9 VSUBS 1.39871f
C260 VSUBS.t17 VSUBS 3.08599f
C261 VSUBS.t33 VSUBS 1.39871f
C262 VDD.t22 VSUBS 1.11534f
C263 VDD.t10 VSUBS 2.18625f
C264 VDD.t14 VSUBS 5.57989f
C265 VDD.t1 VSUBS 7.76844f
C266 VDD.n0 VSUBS 1.16392f
C267 VDD.n1 VSUBS 1.16392f
C268 VDD.n2 VSUBS 1.17094f
C269 VDD.n4 VSUBS 1.17094f
C270 VDD.t20 VSUBS 0.3143f
C271 VDD.n6 VSUBS 0.14952f
C272 VDD.t7 VSUBS 0.3143f
C273 VDD.n7 VSUBS 0.14952f
C274 VDD.n8 VSUBS 1.14368f
C275 VDD.t24 VSUBS 0.7659f
C276 VDD.t21 VSUBS 3.16723f
C277 VDD.t12 VSUBS 3.42364f
C278 VDD.t19 VSUBS 2.65686f
C279 VDD.t18 VSUBS 0.91574f
C280 VDD.t17 VSUBS 0.73259f
C281 VDD.t16 VSUBS 0.73259f
C282 VDD.t15 VSUBS 0.77535f
C283 VDD.t23 VSUBS 0.31511f
C284 VDD.t13 VSUBS 1.14218f
C285 VDD.n9 VSUBS 1.14368f
C286 VDD.t11 VSUBS 0.7659f
C287 VDD.t9 VSUBS 3.16723f
C288 VDD.t0 VSUBS 3.42364f
C289 VDD.t6 VSUBS 2.65686f
C290 VDD.t5 VSUBS 0.91574f
C291 VDD.t4 VSUBS 0.73259f
C292 VDD.t3 VSUBS 0.73259f
C293 VDD.t2 VSUBS 0.77535f
C294 VDD.t8 VSUBS 0.31511f
C295 VDD.t25 VSUBS 2.13671f
.ends
