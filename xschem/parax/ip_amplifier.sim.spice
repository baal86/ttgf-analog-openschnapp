* NGSPICE file created from ip_amplifier_parax.ext - technology: gf180mcuD

.subckt ip_amplifier_parax VDD OUTP INP INN vsubs
X0 VDD.t10 a_1592_368# OUTP VDD.t11 pfet_03v3 ad=5.28p pd=24.88u as=6.015p ps=13.1u w=12u l=0.5u
X1 vsubs.t9 a_1080_400# a_1404_2016# vsubs.t8 nfet_03v3 ad=3.03p pd=7.2u as=3.03p ps=7.2u w=6u l=2u
X2 OUTP w_13700_140# cap_pmos_03v3 c_width=13.5u c_length=18u
X3 a_6130_2884# w_13700_140# cap_pmos_03v3 c_width=13.5u c_length=18u
X4 a_240_2922# a_520_400# vsubs.t12 ppolyf_u_1k r_width=1u r_length=12u
X5 a_18380_2922# a_18100_400# w_13700_140# ppolyf_u_1k r_width=1u r_length=12u
X6 OUTP a_6130_2884# vsubs.t16 vsubs.t15 nfet_03v3 ad=6.03p pd=13.2u as=6.03p ps=13.2u w=12u l=0.5u
X7 a_800_2922# a_1080_400# vsubs.t13 ppolyf_u_1k r_width=1u r_length=12u
X8 OUTP a_6130_2884# vsubs.t2 vsubs.t15 nfet_03v3 ad=6.03p pd=13.2u as=5.28p ps=24.88u w=12u l=0.5u
X9 vsubs.t16 a_6130_2884# OUTP vsubs.t15 nfet_03v3 ad=5.28p pd=24.88u as=6.03p ps=13.2u w=12u l=0.5u
X10 vsubs.t16 a_6130_2884# OUTP vsubs.t15 nfet_03v3 ad=6.03p pd=13.2u as=6.03p ps=13.2u w=12u l=0.5u
X11 a_18940_2922# a_18660_400# w_13700_140# ppolyf_u_1k r_width=1u r_length=12u
X12 a_19500_2922# a_19220_400# w_13700_140# ppolyf_u_1k r_width=1u r_length=12u
X13 a_4374_1878# a_1592_368# a_4186_1878# VDD.t2 pfet_03v3 ad=3.03p pd=7.2u as=2.64p ps=12.88u w=6u l=0.5u
X14 a_17820_2922# VDD.t1 w_13700_140# ppolyf_u_1k r_width=1u r_length=12u
X15 a_1592_368# a_1592_368# a_4186_430# VDD.t2 pfet_03v3 ad=3.03p pd=7.2u as=2.64p ps=12.88u w=6u l=0.5u
X16 vsubs.t2 a_6130_536# a_6130_536# vsubs.t1 nfet_03v3 ad=2.64p pd=12.88u as=2.64p ps=12.88u w=6u l=5u
X17 a_4186_430# a_1592_368# a_1592_368# VDD.t5 pfet_03v3 ad=3.03p pd=7.2u as=3.03p ps=7.2u w=6u l=0.5u
X18 a_240_2922# VDD vsubs.t0 ppolyf_u_1k r_width=1u r_length=12u
X19 a_1080_400# a_1080_400# a_1404_2016# vsubs.t6 nfet_03v3 ad=3.03p pd=7.2u as=3.03p ps=7.2u w=6u l=0.5u
X20 a_4186_1878# a_1592_368# a_4374_1878# VDD.t5 pfet_03v3 ad=3.03p pd=7.2u as=3.03p ps=7.2u w=6u l=0.5u
X21 a_4186_430# a_1592_368# a_1592_368# VDD.t3 pfet_03v3 ad=3.03p pd=7.2u as=3.03p ps=7.2u w=6u l=0.5u
X22 vsubs.t2 a_6130_536# a_6130_2884# vsubs.t3 nfet_03v3 ad=2.64p pd=12.88u as=2.64p ps=12.88u w=6u l=5u
X23 VDD.t8 a_1592_368# a_4186_430# VDD.t6 pfet_03v3 ad=2.64p pd=12.88u as=3.03p ps=7.2u w=6u l=2u
X24 a_4374_1878# INN a_6130_536# VDD.t0 pfet_03v3 ad=7.92p pd=36.88u as=7.92p ps=36.88u w=18u l=5u
X25 a_1080_400# a_1080_400# a_1404_2016# vsubs.t4 nfet_03v3 ad=3.03p pd=7.2u as=2.64p ps=12.88u w=6u l=0.5u
X26 a_4186_1878# a_1592_368# a_4374_1878# VDD.t3 pfet_03v3 ad=3.03p pd=7.2u as=3.03p ps=7.2u w=6u l=0.5u
X27 a_1592_368# a_1592_368# a_4186_430# VDD.t4 pfet_03v3 ad=3.03p pd=7.2u as=3.03p ps=7.2u w=6u l=0.5u
X28 a_19500_2922# w_13700_140# w_13700_140# ppolyf_u_1k r_width=1u r_length=12u
X29 a_1592_368# a_1080_400# a_1404_368# vsubs.t6 nfet_03v3 ad=3.03p pd=7.2u as=3.03p ps=7.2u w=6u l=0.5u
X30 a_18940_2922# a_19220_400# w_13700_140# ppolyf_u_1k r_width=1u r_length=12u
X31 a_800_2922# a_520_400# vsubs.t14 ppolyf_u_1k r_width=1u r_length=12u
X32 a_1592_368# a_1080_400# a_1404_368# vsubs.t4 nfet_03v3 ad=3.03p pd=7.2u as=2.64p ps=12.88u w=6u l=0.5u
X33 a_18380_2922# a_18660_400# w_13700_140# ppolyf_u_1k r_width=1u r_length=12u
X34 a_1404_2016# a_1080_400# a_1080_400# vsubs.t7 nfet_03v3 ad=3.03p pd=7.2u as=3.03p ps=7.2u w=6u l=0.5u
X35 VDD.t7 a_1592_368# a_4186_1878# VDD.t6 pfet_03v3 ad=2.64p pd=12.88u as=3.03p ps=7.2u w=6u l=2u
X36 a_17820_2922# a_18100_400# w_13700_140# ppolyf_u_1k r_width=1u r_length=12u
X37 a_1404_368# a_1080_400# a_1592_368# vsubs.t7 nfet_03v3 ad=3.03p pd=7.2u as=3.03p ps=7.2u w=6u l=0.5u
X38 a_1404_368# a_1080_400# a_1592_368# vsubs.t5 nfet_03v3 ad=3.03p pd=7.2u as=3.03p ps=7.2u w=6u l=0.5u
X39 a_1404_2016# a_1080_400# a_1080_400# vsubs.t5 nfet_03v3 ad=3.03p pd=7.2u as=3.03p ps=7.2u w=6u l=0.5u
X40 vsubs.t11 a_1080_400# a_1404_368# vsubs.t8 nfet_03v3 ad=2.64p pd=12.88u as=3.03p ps=7.2u w=6u l=2u
X41 a_4374_1878# a_1592_368# a_4186_1878# VDD.t4 pfet_03v3 ad=3.03p pd=7.2u as=3.03p ps=7.2u w=6u l=0.5u
X42 a_1404_2016# a_1080_400# vsubs.t9 vsubs.t10 nfet_03v3 ad=2.64p pd=12.88u as=3.03p ps=7.2u w=6u l=2u
X43 OUTP a_1592_368# VDD.t10 VDD.t9 pfet_03v3 ad=6.015p pd=13.1u as=5.28p ps=24.88u w=12u l=0.5u
X44 a_6130_2884# INP a_4374_1878# VDD.t0 pfet_03v3 ad=8.294p pd=37.56u as=7.92p ps=36.88u w=18u l=5u
R0 VDD.t0 VDD.t9 721.385
R1 VDD.t6 VDD.t1 542.768
R2 VDD.n4 VDD.n3 0.205961
R3 VDD.n4 VDD.t1 307.44
R4 VDD.n0 VDD.n2 151.849
R5 VDD.n2 VDD.t1 3.10736
R6 VDD.n1 VDD.t0 160.377
R7 VDD.t5 VDD.t6 141.51
R8 VDD.n0 VDD.t2 105.242
R9 VDD.t11 VDD.n4 102.727
R10 VDD.t2 VDD.t3 94.3401
R11 VDD.t3 VDD.t4 94.3401
R12 VDD.t4 VDD.t5 94.3401
R13 VDD.t9 VDD.t11 94.3401
R14 VDD.n3 VDD.n1 7.2039
R15 VDD.n0 VDD.t7 5.3105
R16 VDD.n2 VDD.n1 3.12014
R17 VDD.t8 VDD.n0 5.1005
R18 VDD.t1 VDD.t10 3.8705
R19 VDD.n3 VDD.t10 3.0059
R20 VDD.n1 VDD.t7 2.27796
R21 VDD.t1 VDD.t8 2.0705
R22 VDD VDD.t1 1.31028
R23 vsubs.n10 vsubs.n0 282286
R24 vsubs.n7 vsubs.n0 281357
R25 vsubs.n9 vsubs.n6 144219
R26 vsubs.n8 vsubs.n6 144219
R27 vsubs.n9 vsubs.t3 1136.3
R28 vsubs.t1 vsubs.n8 1068.89
R29 vsubs.t15 vsubs.t1 962.963
R30 vsubs.n4 vsubs.n3 6.96396
R31 vsubs.n5 vsubs.n3 962.5
R32 vsubs.n1 vsubs.n2 1.47068
R33 vsubs.t3 vsubs.t15 852.222
R34 vsubs.t10 vsubs.t8 557.144
R35 vsubs.t8 vsubs.t7 417.858
R36 vsubs.n6 vsubs.t10 378.858
R37 vsubs.t4 vsubs.t13 336.144
R38 vsubs.t5 vsubs.t4 278.572
R39 vsubs.t6 vsubs.t5 278.572
R40 vsubs.t7 vsubs.t6 278.572
R41 vsubs.t0 vsubs.n3 269.44
R42 vsubs.t12 vsubs.t0 260
R43 vsubs.t14 vsubs.t12 260
R44 vsubs.t13 vsubs.t14 260
R45 vsubs.n7 vsubs.n1 24.095
R46 vsubs.n5 vsubs.n10 24.095
R47 vsubs.n0 vsubs.t2 19.9163
R48 vsubs.n2 vsubs.n0 18.2663
R49 vsubs.t9 vsubs.n5 13.3655
R50 vsubs.n1 vsubs.n4 12.9427
R51 vsubs.n8 vsubs.n7 12.0375
R52 vsubs.n10 vsubs.n9 12.0375
R53 vsubs.t11 vsubs.n4 0.0966006
R54 vsubs vsubs.t9 4.6355
R55 vsubs vsubs.n3 2.65844
R56 vsubs.n2 vsubs.t16 0.0290295
R57 vsubs.n1 vsubs.t2 1.44204
R58 vsubs.n5 vsubs.t2 1.13421
C0 VDD a_6130_2884# 2.88847f
C1 OUTP a_6130_2884# 2.85986f
C2 VDD a_4186_430# 1.2083f
C3 VDD a_1404_368# 0.39705f
C4 INP a_1592_368# 0.27078f
C5 INP a_4186_1878# 0.02072f
C6 a_1080_400# a_4186_430# 0.00664f
C7 a_1080_400# a_1404_368# 1.28682f
C8 INP VDD 1.68936f
C9 OUTP INP 0.0574f
C10 a_18660_400# w_13700_140# 0.47555f
C11 a_18660_400# VDD 0.05835f
C12 OUTP a_18660_400# 0
C13 w_13700_140# a_19500_2922# 0.49473f
C14 a_18380_2922# w_13700_140# 0.42251f
C15 OUTP a_18380_2922# 0
C16 INN a_1592_368# 0.03165f
C17 VDD INN 1.92729f
C18 OUTP INN 0.05787f
C19 a_4374_1878# a_1592_368# 1.25398f
C20 a_4186_430# a_1404_368# 0.00113f
C21 a_4374_1878# a_4186_1878# 1.9199f
C22 VDD a_4374_1878# 2.17436f
C23 OUTP a_4374_1878# 0.00862f
C24 INP a_6130_2884# 1.05279f
C25 a_1080_400# a_4374_1878# 0
C26 w_13700_140# a_18940_2922# 0.42251f
C27 a_1404_2016# a_1592_368# 0.38572f
C28 a_1404_2016# VDD 0.24358f
C29 a_18660_400# a_6130_2884# 0
C30 OUTP a_18940_2922# 0
C31 a_1080_400# a_1404_2016# 3.68312f
C32 a_240_2922# a_1080_400# 0
C33 a_19500_2922# a_6130_2884# 0.02981f
C34 a_18380_2922# a_6130_2884# 0.02734f
C35 INN a_6130_2884# 0.01134f
C36 INN a_4186_430# 0.01705f
C37 a_19220_400# w_13700_140# 0.52118f
C38 a_4374_1878# a_6130_2884# 0.0981f
C39 a_4186_430# a_4374_1878# 0.0226f
C40 a_1404_2016# a_800_2922# 0.05993f
C41 INP INN 0.04056f
C42 VDD a_520_400# 0.09503f
C43 a_240_2922# a_800_2922# 0.03359f
C44 a_19220_400# VDD 0.057f
C45 INP a_4374_1878# 1.0023f
C46 a_1080_400# a_520_400# 0.03951f
C47 w_13700_140# a_6130_536# 0
C48 a_18100_400# w_13700_140# 0.47678f
C49 a_6130_536# a_1592_368# 0.06783f
C50 a_1404_2016# a_1404_368# 0.00526f
C51 a_18940_2922# a_6130_2884# 0.02772f
C52 w_13700_140# a_17820_2922# 0.49495f
C53 VDD a_6130_536# 2.93407f
C54 OUTP a_6130_536# 1.74613f
C55 a_18100_400# VDD 0.11595f
C56 OUTP a_18100_400# 0
C57 OUTP a_17820_2922# 0.00126f
C58 INN a_4374_1878# 0.88702f
C59 a_19220_400# a_6130_2884# 0
C60 a_19500_2922# a_18940_2922# 0.0444f
C61 a_18380_2922# a_18940_2922# 0.0444f
C62 a_6130_2884# a_6130_536# 0.57657f
C63 a_4186_430# a_6130_536# 0.00418f
C64 w_13700_140# VDD 2.96027f
C65 OUTP w_13700_140# 7.2166f
C66 a_4186_1878# a_1592_368# 1.19804f
C67 VDD a_1592_368# 6.02661f
C68 OUTP a_1592_368# 0.48086f
C69 INP a_6130_536# 0.01207f
C70 a_19220_400# a_18660_400# 0.0444f
C71 VDD a_4186_1878# 1.00663f
C72 a_6130_2884# a_17820_2922# 0.02721f
C73 OUTP VDD 2.59684f
C74 a_1080_400# a_1592_368# 1.23245f
C75 a_1080_400# a_4186_1878# 0
C76 a_1080_400# VDD 0.19141f
C77 a_240_2922# a_1404_2016# 0.00389f
C78 a_18660_400# a_18100_400# 0.0444f
C79 INN a_6130_536# 1.04935f
C80 a_1080_400# a_800_2922# 0.0033f
C81 w_13700_140# a_6130_2884# 7.81815f
C82 a_18380_2922# a_17820_2922# 0.0444f
C83 a_4374_1878# a_6130_536# 0.09719f
C84 a_6130_2884# a_1592_368# 0.54222f
C85 a_1592_368# a_1404_368# 1.48399f
C86 a_4186_430# a_1592_368# 2.60094f
C87 a_4186_1878# a_6130_2884# 0.0038f
C88 a_4186_430# a_4186_1878# 0.01085f
C89 VDD vsubs 81.98397f
C90 a_19500_2922# vsubs 0.09294f
C91 a_19220_400# vsubs 0.09522f
C92 a_18940_2922# vsubs 0.09183f
C93 a_18660_400# vsubs 0.09522f
C94 a_18380_2922# vsubs 0.09183f
C95 a_18100_400# vsubs 0.09522f
C96 a_17820_2922# vsubs 0.09294f
C97 a_6130_536# vsubs 0.06589f
C98 a_4186_430# vsubs 0.05768f
C99 a_6130_2884# vsubs 0.06683f
C100 a_4186_1878# vsubs 0.01223f
C101 a_4374_1878# vsubs 0.16921f
C102 a_1404_368# vsubs 0.6034f
C103 a_800_2922# vsubs 0.48473f
C104 a_520_400# vsubs 0.47481f
C105 a_240_2922# vsubs 0.51713f
C106 a_1404_2016# vsubs 4.20448f
C107 w_13700_140# vsubs 0.11613p
C108 vsubs.t2 vsubs 1.39871f
C109 vsubs.t9 vsubs 2.2947f
C110 VDD.t10 vsubs 2.18366f
C111 VDD.t1 vsubs 6.88845f
C112 VDD.n0 vsubs 1.1511f
C113 VDD.n1 vsubs 1.15803f
C114 VDD.t7 vsubs 0.31084f
C115 VDD.n3 vsubs 0.14787f
C116 VDD.n4 vsubs 1.13108f
C117 VDD.t11 vsubs 0.75746f
C118 VDD.t9 vsubs 3.13233f
C119 VDD.t0 vsubs 3.38591f
C120 VDD.t6 vsubs 2.62758f
C121 VDD.t5 vsubs 0.90564f
C122 VDD.t4 vsubs 0.72452f
C123 VDD.t3 vsubs 0.72452f
C124 VDD.t2 vsubs 0.76681f
C125 VDD.t8 vsubs 0.31164f
.ends
