* NGSPICE file created from ip_current_source_parax.ext - technology: gf180mcuD

.subckt ip_current_source_parax VDD vsubs src_b src_a
X0 src_a a_2720_3600# a_3152_2676# vsubs.t3 nfet_06v0 ad=2.2p pd=10.88u as=2.2p ps=10.88u w=5u l=0.7u
X1 a_3152_2676# a_2720_3600# src_a vsubs.t3 nfet_06v0 ad=2.2p pd=10.88u as=2.2p ps=10.88u w=5u l=0.7u
X2 a_2440_4922# a_2720_3600# vsubs.t6 ppolyf_u_1k_6p0 r_width=1u r_length=6u
X3 a_1880_4922# a_1880_3382# vsubs.t6 ppolyf_u_1k_6p0 r_width=1u r_length=6u
X4 a_1880_3382# VDD vsubs.t7 ppolyf_u_1k_6p0 r_width=1u r_length=6u
X5 a_2440_4922# a_2440_3382# vsubs.t6 ppolyf_u_1k_6p0 r_width=1u r_length=6u
X6 a_2440_3382# a_2160_2060# vsubs.t7 ppolyf_u_1k_6p0 r_width=1u r_length=6u
X7 a_2720_3600# a_2720_3600# vsubs vsubs.t5 nfet_06v0 ad=2.2p pd=10.88u as=2.2p ps=10.88u w=5u l=1u
X8 a_3152_4024# a_2720_3600# vsubs.t2 vsubs.t1 nfet_06v0 ad=0.22p pd=1.88u as=0.22p ps=1.88u w=0.5u l=5u
X9 a_1880_4922# a_2160_3382# vsubs.t6 ppolyf_u_1k_6p0 r_width=1u r_length=6u
X10 a_2160_3382# a_2160_2060# vsubs.t7 ppolyf_u_1k_6p0 r_width=1u r_length=6u
X11 src_b a_2720_3600# a_3152_4024# vsubs.t0 nfet_06v0 ad=2.2p pd=10.88u as=2.2p ps=10.88u w=5u l=0.7u
X12 a_3152_4024# a_2720_3600# src_b vsubs.t0 nfet_06v0 ad=2.2p pd=10.88u as=2.2p ps=10.88u w=5u l=0.7u
X13 vsubs.t2 a_2720_3600# a_3152_2676# vsubs.t4 nfet_06v0 ad=0.22p pd=1.88u as=0.22p ps=1.88u w=0.5u l=5u
R0 vsubs.t2 vsubs.t6 896.072
R1 vsubs.t7 vsubs.t5 675.537
R2 vsubs.t3 vsubs.t7 457.322
R3 vsubs.t2 vsubs.t4 429.464
R4 vsubs.t6 vsubs.t1 229.821
R5 vsubs.t2 vsubs.t0 844.917
R6 vsubs vsubs.t5 406.805
R7 vsubs.t4 vsubs.t3 4.64336
R8 vsubs.t1 vsubs.t0 4.64336
R9 vsubs vsubs.t2 2.62523
C0 a_2160_2060# a_2440_3382# 0.0035f
C1 a_2160_3382# a_3152_2676# 0
C2 a_3152_4024# src_b 0.3405f
C3 a_2160_3382# a_2720_3600# 0.00101f
C4 a_1880_3382# src_a 0
C5 a_2440_4922# src_b 0
C6 VDD a_2720_3600# 0
C7 a_3152_2676# a_2720_3600# 0.80034f
C8 a_2440_4922# a_3152_4024# 0.01209f
C9 src_a a_2160_3382# 0
C10 a_2160_3382# a_2440_3382# 0.083f
C11 a_3152_4024# a_1880_4922# 0
C12 src_a a_3152_2676# 0.32414f
C13 src_a a_2720_3600# 0.22616f
C14 a_2440_4922# a_1880_4922# 0.03282f
C15 a_2440_3382# a_3152_2676# 0
C16 a_2440_3382# a_2720_3600# 0.05231f
C17 a_1880_3382# a_1880_4922# 0.0035f
C18 src_b a_2720_3600# 0.22364f
C19 src_a a_2440_3382# 0
C20 a_3152_4024# a_3152_2676# 0.00497f
C21 a_3152_4024# a_2720_3600# 0.46427f
C22 a_2160_3382# a_2160_2060# 0.0035f
C23 a_2440_4922# a_2720_3600# 0.00462f
C24 a_2160_3382# a_1880_4922# 0.0035f
C25 a_2160_2060# VDD 0.02703f
C26 src_a src_b 0.00793f
C27 a_2160_2060# a_2720_3600# 0.00845f
C28 a_1880_3382# a_2160_3382# 0.083f
C29 a_1880_4922# a_2720_3600# 0
C30 a_1880_3382# VDD 0.00434f
C31 a_1880_3382# a_3152_2676# 0
C32 a_1880_3382# a_2720_3600# 0
C33 a_2440_4922# a_2440_3382# 0.0035f
C34 src_a vsubs 2.77209f
C35 VDD vsubs 0.42063f
C36 src_b vsubs 0.10673f
C37 a_2160_2060# vsubs 0.48325f
C38 a_3152_2676# vsubs 2.97236f
C39 a_2440_3382# vsubs 0.34993f
C40 a_2440_4922# vsubs 0.49389f
C41 a_2160_3382# vsubs 0.33031f
C42 a_1880_3382# vsubs 0.40108f
C43 a_1880_4922# vsubs 0.50811f
C44 a_3152_4024# vsubs 0.68394f
.ends
