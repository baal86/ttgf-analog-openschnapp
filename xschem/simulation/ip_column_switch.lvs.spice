** sch_path: /foss/designs/ttgf-analog-openschnapp/xschem/ip_column_switch.sch
.subckt ip_column_switch cl bus en vsubs
*.PININFO cl:I en:I vsubs:B bus:O
XM1 cl en bus vsubs nfet_06v0 L=0.7u W=0.5u nf=1 ad='int((nf+1)/2) * W/nf * 0.18u' as='int((nf+2)/2) * W/nf * 0.18u' pd='2*int((nf+1)/2) * (W/nf + 0.18u)'
+ ps='2*int((nf+2)/2) * (W/nf + 0.18u)' nrd='0.18u / W' nrs='0.18u / W' sa=0 sb=0 sd=0
D1 vsubs en diode_nd2ps_06v0 area='0.5u * 0.5u ' pj='2*0.5u + 2*0.5u '
XM2 cl en bus vsubs nfet_06v0 L=0.7u W=0.5u nf=1 ad='int((nf+1)/2) * W/nf * 0.18u' as='int((nf+2)/2) * W/nf * 0.18u' pd='2*int((nf+1)/2) * (W/nf + 0.18u)'
+ ps='2*int((nf+2)/2) * (W/nf + 0.18u)' nrd='0.18u / W' nrs='0.18u / W' sa=0 sb=0 sd=0
.ends
