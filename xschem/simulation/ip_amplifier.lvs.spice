** sch_path: /foss/designs/ttgf-analog-openschnapp/xschem/ip_amplifier.sch
.subckt ip_amplifier VDD OUTP INP INN VSUBS
*.PININFO VDD:B VSUBS:B INP:I INN:I OUTP:O
XM1 OUTN INP net1 VDD pfet_03v3 L=0.5u W=15.0u nf=1 ad='int((nf+1)/2) * W/nf * 0.18u' as='int((nf+2)/2) * W/nf * 0.18u' pd='2*int((nf+1)/2) * (W/nf + 0.18u)'
+ ps='2*int((nf+2)/2) * (W/nf + 0.18u)' nrd='0.18u / W' nrs='0.18u / W' sa=0 sb=0 sd=0 m=5
XM2 OUTP INN net8 VDD pfet_03v3 L=0.5u W=15.0u nf=1 ad='int((nf+1)/2) * W/nf * 0.18u' as='int((nf+2)/2) * W/nf * 0.18u' pd='2*int((nf+1)/2) * (W/nf + 0.18u)'
+ ps='2*int((nf+2)/2) * (W/nf + 0.18u)' nrd='0.18u / W' nrs='0.18u / W' sa=0 sb=0 sd=0 m=5
XM5 net3 TCOM VDD VDD pfet_03v3 L=0.5u W=15.0u nf=1 ad='int((nf+1)/2) * W/nf * 0.18u' as='int((nf+2)/2) * W/nf * 0.18u' pd='2*int((nf+1)/2) * (W/nf + 0.18u)'
+ ps='2*int((nf+2)/2) * (W/nf + 0.18u)' nrd='0.18u / W' nrs='0.18u / W' sa=0 sb=0 sd=0 m=3
XM3 TCOM TCOM VDD VDD pfet_03v3 L=0.5u W=15.0u nf=1 ad='int((nf+1)/2) * W/nf * 0.18u' as='int((nf+2)/2) * W/nf * 0.18u' pd='2*int((nf+1)/2) * (W/nf + 0.18u)'
+ ps='2*int((nf+2)/2) * (W/nf + 0.18u)' nrd='0.18u / W' nrs='0.18u / W' sa=0 sb=0 sd=0 m=6
XR6 net6 TCOM VSUBS ppolyf_u_1k r_width=1e-6 r_length=6e-6
XR5 net5 net6 VSUBS ppolyf_u_1k r_width=1e-6 r_length=6e-6
XR7 net4 net5 VSUBS ppolyf_u_1k r_width=1e-6 r_length=6e-6
XR8 net7 net4 VSUBS ppolyf_u_1k r_width=1e-6 r_length=6e-6
Vmeas net7 VSUBS 0
Vmeas1 net3 net2 0
XR9 net8 net2 VSUBS ppolyf_u_1k r_width=1e-6 r_length=4.5e-6
XR1 net1 net2 VSUBS ppolyf_u_1k r_width=2e-6 r_length=1e-6
XR4 net10 net11 VSUBS ppolyf_u_1k r_width=1e-6 r_length=6e-6
XR2 net9 net10 VSUBS ppolyf_u_1k r_width=1e-6 r_length=6e-6
XR10 net13 OUTN VSUBS ppolyf_u_1k r_width=1e-6 r_length=6e-6
XR11 net12 net13 VSUBS ppolyf_u_1k r_width=1e-6 r_length=6e-6
XR12 VSUBS net9 VSUBS ppolyf_u_1k r_width=1e-6 r_length=6e-6
XR13 net11 net12 VSUBS ppolyf_u_1k r_width=1e-6 r_length=6e-6
XR3 net15 net16 VSUBS ppolyf_u_1k r_width=1e-6 r_length=6e-6
XR14 net14 net15 VSUBS ppolyf_u_1k r_width=1e-6 r_length=6e-6
XR15 net18 OUTP VSUBS ppolyf_u_1k r_width=1e-6 r_length=6e-6
XR16 net17 net18 VSUBS ppolyf_u_1k r_width=1e-6 r_length=6e-6
XR17 VSUBS net14 VSUBS ppolyf_u_1k r_width=1e-6 r_length=6e-6
XR18 net16 net17 VSUBS ppolyf_u_1k r_width=1e-6 r_length=6e-6
.ends
