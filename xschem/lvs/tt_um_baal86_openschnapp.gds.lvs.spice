.include ip_column_switch.lvs.spice
.include ip_current_source.lvs.spice
.include ip_pixel_frame_right.lvs.spice
.include ip_pixel_nd2ps.lvs.spice
.include ip_pixel_nd2ps_dummy.lvs.spice
.include ip_amplifier.lvs.spice
.include ip_sicproc.lvs.spice
.include ip_psucap_l.lvs.spice
.include ip_psucap_br.lvs.spice
