** sch_path: /foss/designs/ttgf-analog-openschnapp/xschem/ip_current_source.sch
.subckt ip_current_source vdd src_a vsubs src_b
*.PININFO vdd:B vsubs:B src_a:I src_b:I
XM8 refin refin vsubs vsubs nfet_06v0 L=1u W=5u nf=1 ad='int((nf+1)/2) * W/nf * 0.18u' as='int((nf+2)/2) * W/nf * 0.18u' pd='2*int((nf+1)/2) * (W/nf + 0.18u)'
+ ps='2*int((nf+2)/2) * (W/nf + 0.18u)' nrd='0.18u / W' nrs='0.18u / W' sa=0 sb=0 sd=0
XM5 src_a refin net1 vsubs nfet_06v0 L=0.7u W=5u nf=1 ad='int((nf+1)/2) * W/nf * 0.18u' as='int((nf+2)/2) * W/nf * 0.18u' pd='2*int((nf+1)/2) * (W/nf + 0.18u)'
+ ps='2*int((nf+2)/2) * (W/nf + 0.18u)' nrd='0.18u / W' nrs='0.18u / W' sa=0 sb=0 sd=0
XM2 src_a refin net1 vsubs nfet_06v0 L=0.7u W=5u nf=1 ad='int((nf+1)/2) * W/nf * 0.18u' as='int((nf+2)/2) * W/nf * 0.18u' pd='2*int((nf+1)/2) * (W/nf + 0.18u)'
+ ps='2*int((nf+2)/2) * (W/nf + 0.18u)' nrd='0.18u / W' nrs='0.18u / W' sa=0 sb=0 sd=0
XM3 src_b refin net4 vsubs nfet_06v0 L=0.7u W=5u nf=1 ad='int((nf+1)/2) * W/nf * 0.18u' as='int((nf+2)/2) * W/nf * 0.18u' pd='2*int((nf+1)/2) * (W/nf + 0.18u)'
+ ps='2*int((nf+2)/2) * (W/nf + 0.18u)' nrd='0.18u / W' nrs='0.18u / W' sa=0 sb=0 sd=0
XM6 src_b refin net4 vsubs nfet_06v0 L=0.7u W=5u nf=1 ad='int((nf+1)/2) * W/nf * 0.18u' as='int((nf+2)/2) * W/nf * 0.18u' pd='2*int((nf+1)/2) * (W/nf + 0.18u)'
+ ps='2*int((nf+2)/2) * (W/nf + 0.18u)' nrd='0.18u / W' nrs='0.18u / W' sa=0 sb=0 sd=0
XM4 net1 refin vsubs vsubs nfet_06v0 L=5u W=0.5u nf=1 ad='int((nf+1)/2) * W/nf * 0.18u' as='int((nf+2)/2) * W/nf * 0.18u' pd='2*int((nf+1)/2) * (W/nf + 0.18u)'
+ ps='2*int((nf+2)/2) * (W/nf + 0.18u)' nrd='0.18u / W' nrs='0.18u / W' sa=0 sb=0 sd=0
XM7 net4 refin vsubs vsubs nfet_06v0 L=5u W=0.5u nf=1 ad='int((nf+1)/2) * W/nf * 0.18u' as='int((nf+2)/2) * W/nf * 0.18u' pd='2*int((nf+1)/2) * (W/nf + 0.18u)'
+ ps='2*int((nf+2)/2) * (W/nf + 0.18u)' nrd='0.18u / W' nrs='0.18u / W' sa=0 sb=0 sd=0
XR3 net2 net7 vsubs ppolyf_u_1k_6p0 r_width=1e-6 r_length=6e-6
XR4 net3 net2 vsubs ppolyf_u_1k_6p0 r_width=1e-6 r_length=6e-6
XR5 refin net3 vsubs ppolyf_u_1k_6p0 r_width=1e-6 r_length=6e-6
XR1 net8 net6 vsubs ppolyf_u_1k_6p0 r_width=1e-6 r_length=6e-6
XR2 net6 net5 vsubs ppolyf_u_1k_6p0 r_width=1e-6 r_length=6e-6
XR6 net5 net7 vsubs ppolyf_u_1k_6p0 r_width=1e-6 r_length=6e-6
XR7 net8 vdd vsubs ppolyf_u_1k_6p0 r_width=1e-6 r_length=6e-6
.ends
