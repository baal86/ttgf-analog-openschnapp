** sch_path: /foss/designs/ttgf-analog-openschnapp/xschem/ip_psucap_bottom.sch
.subckt ip_psucap_bottom VDD VSUBS
*.PININFO VDD:B VSUBS:B
XC1 VDD VSUBS cap_nmos_03v3 c_width=3.3e-6 c_length=18.5e-6
.ends
